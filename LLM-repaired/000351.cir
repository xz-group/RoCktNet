Q1 N_Q1_C LO_P N_M1_D npn
Q2 N_Q2_C LO_N N_M1_D npn
Q9 N_Q9_C LO_N N_M2_D npn
Q3 N_Q3_C LO_P N_M2_D npn
Q11 I_P D_P N_Q1_C npn
Q6 I_N D_N N_Q1_C npn
Q7 I_P Q_P N_Q2_C npn
Q4 I_N Q_N N_Q2_C npn
Q12 Q_P I_P N_Q9_C npn
Q5 Q_N I_N N_Q9_C npn
Q8 Q_P D_P N_Q3_C npn
Q10 Q_N D_N N_Q3_C npn
R3 I_P N_TOP 35k
R4 I_N N_TOP 35k
R1 Q_P N_TOP 35k
R2 Q_N N_TOP 35k
R5 N_TOP VDD 24.6k

V0 V0 GND
R1 V0 N1 1
L1 N1 V2 2.2160
C2 V2 GND 1.0883
L3 V2 V4 2.2160
R4 V4 GND 1

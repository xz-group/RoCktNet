M1 n1 n2 n0 GND nmos
M2 label_net_1 n2 n0 GND nmos
M3 label_net_2 n1 VDD VDD pmos
M4 n1 n1 VDD VDD pmos

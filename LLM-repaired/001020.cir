M1 n3 n1 n2 VDD pmos
M2 n3 label_net_0 n4 GND nmos
M3 n4 n3 n7 GND nmos
M4 n4 label_net_2 n6 VDD pmos
M5 n0 n1 n2 VDD pmos
M6 n4 label_net_3 n6 VDD pmos
M7 n6 n1 n2 VDD pmos
M8 n0 label_net_5 n4 GND nmos
M9 n0 n0 n4 GND nmos
M10 n3 n3 n4 GND nmos
M11 n4 n0 n7 GND nmos
M12 n4 n3 n4 GND nmos

M9 n4 Vbias VDD VDD pmos
M41 n4 phi_ch1 n1 GND nmos
M62 n1 n4 VSS GND nmos
M1 n1 In_plus N6 VDD pmos
M8 n3 Vbias VDD VDD pmos
M2 n1 In_minus N6 VDD pmos
M7 N6 Vbias VDD VDD pmos
M32 n3 phi_ch2 n1 GND nmos
M31 n3 n3 n1 GND nmos
M42 n4 n4 n1 GND nmos
M51 n1 n3 VSS GND nmos
M52 n1 n4 n1 GND nmos

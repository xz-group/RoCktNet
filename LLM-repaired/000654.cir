M1b N7 inn GND GND nmos
M2 outp outn N3 GND nmos
M3 P P N9 GND nmos
M2a N9 C1 N8 GND nmos
M1a N8 inp GND GND nmos
M6 P P N10 GND nmos
M7 N3 P GND GND nmos
M8 N6 P GND GND nmos
M9 outn outp N6 GND nmos
M2b N10 C1 N7 GND nmos
M11 P C1 VDD VDD pmos
M12 outn outp VDD VDD pmos
M13 outp outn VDD VDD pmos
M14 P P VDD VDD pmos

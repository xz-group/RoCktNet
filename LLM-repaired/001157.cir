M1 N14 LABEL_NET_0 N18 VDD pmos
M2 N20 N11 N12 VDD pmos
M3 N7 N17 N20 VDD pmos
M4 N13 N12 N9 VDD pmos
M5 N18 N11 LABEL_NET_2 VDD pmos
M6 N5 N1 N8 GND nmos
M7 N1 N10 N19 VDD pmos
M8 N19 N9 LABEL_NET_3 VDD pmos
M9 N6 N16 N13 VDD pmos
M10 N4 N1 N6 GND nmos
M11 N6 N6 GND GND nmos
M12 N4 N1 N6 GND nmos
M13 GND N7 GND GND nmos
M14 N8 N2 GND GND nmos
M15 N7 N0 N4 GND nmos
M16 N6 N0 N4 GND nmos
M17 N1 N0 N5 GND nmos
M18 N14 N4 N4 GND nmos
M19 N14 LABEL_NET_4 N4 GND nmos

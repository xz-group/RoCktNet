M1 N14 Vb4 N18 VDD pmos
M2 N20 Vb5 N12 VDD pmos
M3 Vo_plus N17 N20 VDD pmos
M4 N13 N12 N9 VDD pmos
M5 N18 Vb5 LABEL_NET_2 VDD pmos
M6 N5 N1 N8 GND nmos
M7 N1 N10 N19 VDD pmos
M8 N19 N9 LABEL_NET_3 VDD pmos
M9 Vo_minus N16 N13 VDD pmos
M10 N4 N1 Vo_minus GND nmos
MT2 Vo_minus Vo_minus GND GND nmos
M12 N4 N1 Vo_minus GND nmos
MT1 GND Vo_plus GND GND nmos
M14 N8 CMFB GND GND nmos
M15 Vo_plus Vb3 N4 GND nmos
M16 Vo_minus Vb3 N4 GND nmos
M17 N1 Vb3 N5 GND nmos
M18 N14 N4 N4 GND nmos
M19 N14 Vin_plus N4 GND nmos

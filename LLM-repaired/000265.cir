M4 Out VDD VDD VDD pmos
I1 N3 GND
I2 VDD N0
I3 N1 GND
M5 VDD N1 VDD VDD pmos
M3 VDD VDD VDD VDD pmos
M12 N0 N0 GND GND nmos
M7 GND Dwn_bar N4 VDD pmos
I4 VDD N4
M10 Out GND GND GND nmos
M11 GND N0 GND GND nmos
M6 N1 N1 VDD VDD pmos
M9 GND GND GND GND nmos
M2 VDD Up_bar N3 GND nmos
M1 VDD Up N3 GND nmos
M8 GND Dwn N4 VDD pmos

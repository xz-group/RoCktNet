M1 n2 VDD VDD VDD pmos
I1 n3 GND
I2 VDD n0
I3 n1 GND
M2 VDD n1 VDD VDD pmos
M3 VDD VDD VDD VDD pmos
M4 n0 n0 GND GND nmos
M5 GND label_net_0 n4 VDD pmos
I4 VDD n4
M6 n2 GND GND GND nmos
M7 GND n0 GND GND nmos
M8 n1 n1 VDD VDD pmos
M9 GND GND GND GND nmos
M10 VDD label_net_1 n3 GND nmos
M11 VDD label_net_2 n3 GND nmos
M12 GND label_net_3 n4 VDD pmos

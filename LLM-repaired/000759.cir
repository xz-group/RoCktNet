I1 N1 GND
I2 N2 GND
M4 OUT- IN+ N1 N1 nmos
M3 OUT+ IN- N2 N2 nmos
M2 OUT- OUT- VDD VDD pmos
M1 OUT+ OUT+ VDD VDD pmos
M5 N2 IN+ N1 N1 nmos
M6 N2 IN- N1 N1 pmos

R1 GND IN1 50
R2 GND IN2 50
Q2 GND IN1 OUT1 npn
Q1 GND IN2 OUT2 npn
I2 OUT1 VEE
I1 OUT2 VEE

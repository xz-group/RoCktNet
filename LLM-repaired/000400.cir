M1 VDD n1 VDD VDD pmos
M2 n1 label_net_0 VDD VDD pmos
M3 n0 label_net_1 n2 GND nmos
M4 n4 n0 VDD VDD pmos
M5 n4 n0 GND GND nmos
M6 n1 label_net_2 n2 GND nmos
M7 n0 label_net_3 VDD VDD pmos
M8 n1 n0 VDD VDD pmos
M9 n2 label_net_4 GND GND nmos
M10 n3 n1 GND GND nmos
M11 n3 n1 VDD VDD pmos

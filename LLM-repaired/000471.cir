X1 n6 label_net_0 n4 amplifier
M1 n0 label_net_1 n1 GND nmos
M2 n3 label_net_2 n2 VDD pmos
X2 label_net_3 n0 n8 amplifier
M3 n4 label_net_4 n1 GND nmos
M4 n2 label_net_5 VDD VDD pmos
M5 n5 label_net_6 VDD VDD pmos
M6 n3 n8 n0 GND nmos
M7 n7 n6 n4 GND nmos
M8 n7 label_net_7 n5 VDD pmos

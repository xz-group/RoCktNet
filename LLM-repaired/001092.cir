M7 N_M7_D N_M7_D VDD VDD pmos
M8 VOUT N_M7_D VDD VDD pmos
M6 N_M7_D VIN1 N_TAIL GND nmos
M2 VOUT VIN2 N_TAIL GND nmos
M3 N_I0_BOT VOUT N_TAIL GND nmos
M5 N_TAIL N_I0_BOT GND GND nmos
M9 VIN1 VIN1 N_M9_S GND nmos
M1 VIN2 VIN2 N_M1_S GND nmos
M4 IOUT VOUT N_M4_S GND nmos
C1 VOUT GND
I0 VDD N_I0_BOT
I1 N_M9_S GND
I2 N_M1_S GND
I3 N_M4_S GND

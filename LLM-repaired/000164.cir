M1 n1 label_net_0 n0 GND nmos
M2 n0 n1 n2 VDD pmos
M3 n7 label_net_1 n3 GND nmos
M4 n6 label_net_2 n3 GND nmos
M5 n3 label_net_3 GND GND nmos
M6 n5 label_net_4 GND GND nmos
M7 n6 n4 n0 VDD pmos
M8 n7 n4 n1 VDD pmos
M9 n0 n1 n5 GND nmos
M10 n1 n0 n5 GND nmos
M11 n1 n0 n2 VDD pmos

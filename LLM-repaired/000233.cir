M6 V1outp V1outp N2 GND nmos
M3 N0 V1outp N7 GND nmos
M7 V1outn V1outp VDD VDD pmos
M4 N2 V1outn N6 GND nmos
M9 V1outn V1outp VDD VDD pmos
M10 V1outp V1outn VDD VDD pmos
M1 N7 Vinp Vss GND nmos
M2 N6 Vinn Vss GND nmos
M5 V1outn V1outp N0 GND nmos
M8 V1outp V1outp VDD VDD pmos

I1 n3 GND
I2 n1 GND
I3 n6 GND
I4 n0 GND
I5 n2 GND
I6 n5 GND
Q1 VDD label_net_0 n3 npn
Q2 VDD label_net_1 n6 npn
Q3 VDD label_net_2 n2 npn
Q4 VDD label_net_7 n1 npn
Q5 VDD label_net_8 n5 npn
Q6 n4 label_net_15 n1 npn
Q7 n4 label_net_16 n0 npn
Q8 n4 label_net_17 n3 npn
Q9 n4 label_net_18 n5 npn
Q10 VDD label_net_19 n0 npn
Q11 n4 label_net_20 n6 npn
Q12 n4 label_net_21 n2 npn

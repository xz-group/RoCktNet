M1 VO VO GND GND nmos
M2 VO V1 VO VO nmos
M3 VO V2 VO VO nmos
M4 VO V3 VO VO nmos

M1 Q DB GND GND nmos
M2 QB Q GND GND nmos
M3 QB D GND GND nmos
M4 Q QB GND GND nmos
M5 Q CLK VDD VDD pmos
M6 QB CLK VDD VDD pmos

I1 n0 GND
M1 n3 label_net_0 n0 GND nmos
M2 n1 n1 n2 VDD pmos
M3 n1 label_net_1 n0 GND nmos
M4 n3 n1 n2 VDD pmos

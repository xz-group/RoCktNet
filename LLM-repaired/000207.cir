X1 n1 label_net_0 n2 amplifier
X2 n7 VDD n5 amplifier
I1 VDD n2
I2 n9 GND
V1 n3 n0
M1 n5 n4 VDD VDD pmos
Q1 n6 n7 n9 npn
M2 n4 n4 VDD VDD pmos
Q2 n4 n0 n1 npn
Q3 n2 n3 n1 npn
Q4 VDD n7 n8 npn
Q5 n5 n10 n9 npn
Q6 n8 label_net_2 label_net_1 npn
Q7 label_net_3 n10 n8 npn

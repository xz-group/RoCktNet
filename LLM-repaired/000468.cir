I1 n2 n0
M1 n3 n3 n2 VDD pmos
M2 n3 n0 GND GND nmos
M3 n1 n4 GND GND nmos
M4 n0 n0 GND GND nmos
M5 n0 n4 GND GND nmos
M6 n1 n3 n2 VDD pmos

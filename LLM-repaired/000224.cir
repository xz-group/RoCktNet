MN1 N0 N0 GND GND nmos
MN0 N0 N0 GND GND nmos
MP0 N0 N0 VDD VDD pmos
MP1 N0 N0 VDD VDD pmos
MN2 N0 VDD N0 GND nmos
MN3 VDD VDD N0 GND nmos

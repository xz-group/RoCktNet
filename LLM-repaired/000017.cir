M1 n1 n7 VDD VDD pmos
M2 n3 n6 n3 GND nmos
M3 n3 label_net_0 VDD VDD pmos
M4 n0 n7 n1 VDD pmos
M5 n2 n3 VDD VDD pmos
M6 n4 n3 n3 VDD pmos
M7 n5 label_net_1 n0 VDD pmos
M8 n5 n7 n0 GND nmos
M9 n4 n6 n2 GND nmos
M10 n3 n0 n3 GND nmos

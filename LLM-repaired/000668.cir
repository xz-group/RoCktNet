M1 n9 GND n6 GND nmos
M2 n12 GND n11 GND nmos
I1 VDD n10
M3 n7 GND n3 GND nmos
M4 n13 n0 VDD VDD pmos
M5 n6 n9 GND GND nmos
M6 n5 n9 GND GND nmos
M7 n3 n7 GND GND nmos
M8 n11 n7 GND GND nmos
M9 n0 GND n5 GND nmos
M10 n2 n0 VDD VDD pmos
M11 n9 label_net_0 n10 VDD pmos
M12 n12 n8 n13 VDD pmos
M13 n0 n8 n2 VDD pmos
M14 n7 label_net_1 n10 VDD pmos

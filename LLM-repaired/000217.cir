M1 N0 in1 N2 GND nmos
M2 N0 in2 N1 GND nmos
M3 Vout Vref N2 GND nmos
M4 N2 LABEL_NET_2 GND GND nmos
M5 Vout Vref N1 GND nmos
M6 Vout Vout VDD VDD pmos
M7 N0 N0 VDD VDD pmos
M8 N1 LABEL_NET_3 GND GND nmos
V1 Vref GND

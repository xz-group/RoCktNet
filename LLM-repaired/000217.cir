M1 n0 label_net_0 n2 GND nmos
M2 n0 label_net_1 n1 GND nmos
M3 n3 n4 n2 GND nmos
M4 n2 label_net_2 GND GND nmos
M5 n3 n4 n1 GND nmos
M6 n3 n3 VDD VDD pmos
M7 n0 n0 VDD VDD pmos
M8 n1 label_net_3 GND GND nmos
V1 n4 GND

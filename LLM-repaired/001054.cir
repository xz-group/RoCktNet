M1 n2 n2 VDD VDD pmos
M2 n2 n2 GND GND nmos
M3 n2 n2 VDD VDD pmos
M4 n2 n2 GND GND nmos
M5 n2 n0 n2 GND nmos
M6 n2 n0 n2 GND nmos
M7 label_net_0 n1 n2 GND nmos
M8 n2 n1 n2 GND nmos

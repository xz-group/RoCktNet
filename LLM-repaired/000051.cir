M1 n0 label_net_0 GND GND nmos
M2 n1 label_net_1 GND GND nmos
M3 n1 n0 VDD VDD pmos
M4 n0 n2 VDD VDD pmos
M5 n1 n2 VDD VDD pmos
M6 n0 n1 VDD VDD pmos

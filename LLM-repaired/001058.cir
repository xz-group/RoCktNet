M1 n1 n8 n4 GND nmos
M2 n3 n5 n2 GND nmos
M3 n3 n8 n0 GND nmos
M4 n2 n7 GND GND nmos
M5 n7 n5 n6 GND nmos
M6 n8 n5 GND GND nmos
M7 n0 n4 GND GND nmos
M8 n8 label_net_0 n8 GND nmos
M9 label_net_1 label_net_2 n5 GND nmos
M10 n5 n8 GND GND nmos
M11 n5 n8 label_net_3 VDD pmos
M12 n8 n5 label_net_4 VDD pmos

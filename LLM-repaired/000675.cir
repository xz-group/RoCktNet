M1 N1 VI_PLUS N4 GND nmos
M2 N1 VI_MINUS N1 GND nmos
M3 N0 N0 VDD VDD pmos
M4 VO_MINUS N5 N0 VDD pmos
M5 N0 LABEL_NET_2 VDD VDD pmos
M6 VO_PLUS N6 N0 VDD pmos
M7 N1 LABEL_NET_3 VO_MINUS VO_MINUS pmos
A1 (N1 VCMN) amplifier
A2 (N0 N5 N6) amplifier
M8 N1 N1 N4 GND nmos
M9 N1 N1 N4 GND nmos
M10 VO_PLUS LABEL_NET_5 N1 N6 nmos

M1 n4 label_net_0 n0 GND nmos
M2 n4 n2 VDD VDD pmos
M3 n1 label_net_1 n0 GND nmos
M4 n3 n2 VDD VDD pmos
M5 n4 n1 GND GND nmos
M6 n3 n4 GND GND nmos
M7 n2 label_net_2 n0 VDD pmos

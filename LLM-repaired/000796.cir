M1 VDD CLK N4 VDD pmos
M2 N3 CLK N4 GND nmos
M3 N4 CLK_BAR N3 GND nmos
M4 N2 CLK N3 VDD pmos
M5 N3 CLK_BAR N2 VDD pmos

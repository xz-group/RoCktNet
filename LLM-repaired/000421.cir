Q1 N1 VIN N3 npn
Q2 N2 VINB N4 npn
Q3 VOB LO N1 npn
Q4 VO LOB N1 npn
Q5 VOB LOB N2 npn
Q6 VO LO N2 npn
R1 VCC VOB RL
R2 VCC VO RL
R3 N4 N5 RE
R4 N3 N5 RE
C1 VO VCC CL
C2 VOB VCC CL
I1 N5 VEE

M1 n1 n0 VDD VDD pmos
M2 n2 n0 GND GND nmos
M3 n1 n0 n2 GND nmos
M4 n2 n0 n1 VDD pmos

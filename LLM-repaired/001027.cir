I1 VDD n0
M1 n11 n5 n4 GND nmos
M2 n0 n2 GND GND nmos
M3 n13 n13 VDD VDD pmos
M4 n8 n8 n6 VDD pmos
M5 n8 label_net_0 n7 GND nmos
M6 n9 n12 GND GND nmos
M7 n7 n3 GND GND nmos
M8 n5 n6 VDD VDD pmos
M9 n11 n11 VDD VDD pmos
M10 n1 n13 VDD VDD pmos
M11 n6 label_net_1 n7 GND nmos
M12 n13 n0 n4 GND nmos
M13 n5 n10 GND GND nmos
M14 n9 n11 VDD VDD pmos
M15 n0 n2 GND GND nmos
M16 n1 n0 GND GND nmos
M17 n0 n8 VDD VDD pmos
M18 n6 n6 VDD VDD pmos
M19 n4 n12 GND GND nmos

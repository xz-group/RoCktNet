M1 n0 n0 n2 VDD pmos
M2 n0 label_net_0 n2 VDD pmos
M3 n4 n1 GND GND nmos
M4 n0 n0 n3 GND nmos
M5 n3 n1 GND GND nmos
M6 n0 n0 n4 GND nmos
M7 n0 n0 n2 VDD pmos
M8 n0 label_net_1 n2 VDD pmos

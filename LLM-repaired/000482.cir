M1 n0 label_net_0 VDD VDD pmos
M2 n5 label_net_1 VDD VDD pmos
M3 n1 label_net_2 GND GND nmos
M4 n4 n1 n1 GND nmos
M5 n0 n5 VDD VDD pmos
M6 n2 label_net_3 n1 GND nmos
M7 n0 n5 n2 GND nmos
M8 n5 n0 VDD VDD pmos
M9 n7 n5 VDD VDD pmos
M10 n6 n0 n3 GND nmos
M11 n5 n0 n4 GND nmos
M12 n7 n5 n3 GND nmos
M13 n6 n0 VDD VDD pmos
M14 n0 label_net_4 n5 VDD pmos

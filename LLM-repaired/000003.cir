M1 n1 n2 n5 GND nmos
M2 n5 label_net_0 GND GND nmos
M3 n3 n0 n5 GND nmos
M4 n2 n1 n4 VDD pmos
M5 n0 n3 n4 VDD pmos
M6 n4 label_net_1 VDD VDD pmos

M10 N1 CLK VDD VDD pmos
M8 N2 CLK VDD VDD pmos
M18 N1 IN0 N5 GND nmos
M7 N5 OFFCTRL N3 GND nmos
M16 N1 IN0 N3 GND nmos
M3 N3 CLK GND GND nmos
M2 N2 INB0 N6 GND nmos
M15 N6 OFFCTRL N4 GND nmos
M17 N2 INB0 N4 GND nmos
M12 N4 CLK GND GND nmos
M4 OUT N1 VDD VDD pmos
M5 OUT OUTB VDD VDD pmos
M1 OUTB N2 VDD VDD pmos
M14 OUTB OUT VDD VDD pmos
M9 OUT N1 GND GND nmos
M13 OUT OUTB GND GND nmos
M6 OUTB N2 GND GND nmos
M11 OUTB OUT GND GND nmos

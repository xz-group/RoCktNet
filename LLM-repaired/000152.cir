M1 VON VOP GND GND nmos
M2 VOP VON GND GND nmos
M3 VON VC VDD VDD pmos
M4 VON VIP GND GND nmos
M5 VOP VIN GND GND nmos
M6 VOP VC VDD VDD pmos

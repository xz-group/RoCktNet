I4 LABEL_NET_0 GND
I2 VDD N0
I3 LABEL_NET_1 GND
I1 VDD N1
R N2 GND 1k
C2 N2 GND 1u
C1 N3 GND 1u
Vc N2 N3 DC 0

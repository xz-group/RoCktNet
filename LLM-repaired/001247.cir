I1 LABEL_NET_0 GND
I2 VDD N0
I3 LABEL_NET_1 GND
I4 VDD N1
R1 N2 GND 1k
C1 N2 GND 1u
C2 N3 GND 1u
V1 N2 N3 DC 0

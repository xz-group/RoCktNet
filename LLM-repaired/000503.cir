Ibias VDD N_MB1_D
MB1 N_MB1_D N_MB1_D GND GND nmos
MB3 N_MB2_D N_MB1_D GND GND nmos
MB6 N_MB5_D N_MB1_D GND GND nmos
MB2 N_MB2_D N_MB2_D VDD VDD pmos
MB4 N_MB4_D N_MB5_D VDD VDD pmos
MB5 N_MB5_D N_MB2_D N_MB4_D VDD pmos
MB7 N_MB7_D N_MB5_D VDD VDD pmos
MB8 N_MB8_D N_MB2_D N_MB7_D VDD pmos
MB9 N_MB8_D N_MB8_D GND GND nmos
M15 N_M15_D N_MB5_D VDD VDD pmos
M16 N_M16_D N_MB2_D N_M15_D VDD pmos
M1 N_M1_D IN+ N_M16_D VDD pmos
M2 N_M2_D IN- N_M16_D VDD pmos
M3 N_M1_D N_MB8_D N_M3_S GND nmos
M4 N_M2_D N_MB8_D N_M4_S GND nmos
M5 N_M3_S N_M1_D GND GND nmos
M6 N_M4_S N_M2_D GND GND nmos
M11 N_M11_D N_MB8_D N_M13_D GND nmos
M12 OUT N_MB8_D N_M14_D GND nmos
M13 N_M13_D N_M1_D GND GND nmos
M14 N_M14_D N_M2_D GND GND nmos
M7 N_M7_D N_MB5_D VDD VDD pmos
M8 N_M8_D N_MB5_D VDD VDD pmos
M9 N_M11_D N_M11_D N_M7_D VDD pmos
M10 OUT N_M11_D N_M8_D VDD pmos

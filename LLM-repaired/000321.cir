M1 N0 N0 VDDA VDD pmos
M2 N6 N0 N1 GND nmos
M3 N8 N0 N1 GND nmos
M4 N4 INP N11 GND nmos
M5 N0 N4 N4 GND nmos
M6 Q VDD VDD VDD pmos
I1 N11 GND
M7 Q LABEL_NET_1 VDD VDD pmos
M8 N7 INM N5 GND nmos
M9 N1 CLK GND GND nmos
M10 N0 N7 N7 GND nmos
M11 N0 LABEL_NET_3 VDDA VDD pmos
M12 Q CLK GND GND nmos
M13 N0 LABEL_NET_4 VDDA VDD pmos
M14 N0 LABEL_NET_5 VDDA VDD pmos
M15 QB VDD VDD VDD pmos
M16 N7 N7 N5 GND nmos
M17 N4 REFP N11 GND nmos
M18 N8 CLK VDD VDD pmos
M19 QB CLK VDD VDD pmos
M20 VDD VDD VDD VDD pmos
M21 N6 CLK VDD VDD pmos
I2 N5 GND
M22 VDD VDD N8 GND nmos
M23 VDD VDD VDD VDD pmos
M24 QB VDD GND GND nmos
M25 VDD VDD N6 GND nmos
M26 N0 N7 N0 GND nmos
M27 N0 N4 N4 GND nmos
M28 N0 N0 N0 VDD pmos
M29 CLK VDD Q VDD pmos

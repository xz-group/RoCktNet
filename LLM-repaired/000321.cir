M1 n0 n0 n2 VDD pmos
M2 n6 n0 n1 GND nmos
M3 n8 n0 n1 GND nmos
M4 n4 label_net_0 n11 GND nmos
M5 n0 n4 n4 GND nmos
M6 n9 VDD VDD VDD pmos
I1 n11 GND
M7 n9 label_net_1 VDD VDD pmos
M8 n7 label_net_2 n5 GND nmos
M9 n1 n3 GND GND nmos
M10 n0 n7 n7 GND nmos
M11 n0 label_net_3 n2 VDD pmos
M12 n9 n3 GND GND nmos
M13 n0 label_net_4 n2 VDD pmos
M14 n0 label_net_5 n2 VDD pmos
M15 n10 VDD VDD VDD pmos
M16 n7 n7 n5 GND nmos
M17 n4 label_net_6 n11 GND nmos
M18 n8 n3 VDD VDD pmos
M19 n10 n3 VDD VDD pmos
M20 VDD VDD VDD VDD pmos
M21 n6 n3 VDD VDD pmos
I2 n5 GND
M22 VDD VDD n8 GND nmos
M23 VDD VDD VDD VDD pmos
M24 n10 VDD GND GND nmos
M25 VDD VDD n6 GND nmos
M26 n0 n7 n0 GND nmos
M27 n0 n4 n4 GND nmos
M28 n0 n0 n0 VDD pmos
M29 n3 VDD n9 VDD pmos

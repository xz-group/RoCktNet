A1 (VCO_SUPPLY N2 N1) amplifier
M1 GND GND N1 VDD pmos
M2 GND VCTRL N1 VDD pmos
M3 N1 GND VCO_SUPPLY VDD pmos
M4 N2 GND N0 VDD pmos
M5 GND N2 GND GND nmos
M6 GND GND N0 VDD pmos
M7 N0 GND ADAPTIVE_SUPPLY VDD pmos
M8 GND VDD N0 VDD pmos

M1 GND qn SBL_u_bar GND nmos
M2 SBL_u qn GND GND nmos
M3 q LABEL_NET_0 q GND nmos
M4 SBL_u_bar qn SBL_u_bar VDD pmos
M5 SBL_u_bar q SBL_u_bar GND nmos
M6 SBL_u qn SBL_u VDD pmos
M7 SBL_u q SBL_u GND nmos
M8 SBL_u_bar LABEL_NET_1 SBL_u_bar GND nmos

M16 VDD VREF A GND nmos
M9 A A X GND nmos
M15 X A X GND nmos
M5 X VGM GND GND nmos
M14 N_LS1 VP VDD VDD pmos
M10 Y X N_LS1 VDD pmos
M12 VDD N_LS1 Y GND nmos
M11 Y VGM GND GND nmos
Mp AP Y VDD VDD pmos
M13 AP VREF N_MG1 GND nmos
M17 N_MG1 AP N_MG1 GND nmos
M2 N_MG1 VGM GND GND nmos
M8 GND AP GND GND nmos
M18 VP VP VDD VDD pmos
M19 N_EA2 VP VDD VDD pmos
M7 VP AP N_EA3 GND nmos
M3 N_EA2 VREF N_EA3 GND nmos
M4 N_EA3 VGM GND GND nmos

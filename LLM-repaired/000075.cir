I1 n4 GND
M1 n3 n3 VDD VDD pmos
M2 n1 n2 VDD VDD pmos
M3 n3 label_net_0 n4 GND nmos
M4 n2 n2 VDD VDD pmos
M5 n0 n3 VDD VDD pmos
M6 n0 n1 GND GND nmos
M7 n2 label_net_1 n4 GND nmos
M8 n1 n1 GND GND nmos

M3 N1 N1 VDD VDD pmos
M7 Io2 N5 VDD VDD pmos
M8 N0 N0 GND GND nmos
M6 Io1 N5 VDD VDD pmos
M4 N0 N1 VDD VDD pmos
M5 N5 N5 VDD VDD pmos
M2 N5 GND Ifi GND nmos
M9 Io1 N0 GND GND nmos
M1 N1 Vi Ifi GND nmos
M10 Io2 N0 GND GND nmos

M1 GND GND label_net_0 GND nmos
M2 n1 GND label_net_1 GND nmos
M3 GND n1 GND GND nmos
M4 GND n0 VDD VDD pmos
M5 n0 GND VDD VDD pmos
M6 n1 GND GND GND nmos

M1 GND n1 GND GND nmos
M2 GND n3 GND GND nmos
M3 GND GND GND GND nmos
M4 VDD GND GND GND nmos
M5 n2 n3 GND GND nmos
M6 GND n4 GND GND nmos
M7 VDD n3 VDD VDD pmos
M8 n3 n2 VDD VDD pmos
M9 GND n4 VDD VDD pmos
M10 n5 label_net_0 GND GND nmos
M11 GND n1 VDD VDD pmos
M12 VDD n2 GND VDD pmos
M13 GND GND VDD VDD pmos
M14 n0 GND n4 VDD pmos
M15 GND GND GND GND nmos
M16 GND label_net_2 GND GND nmos
M17 GND VDD GND VDD pmos
M18 GND n3 VDD VDD pmos
M19 n0 GND n3 VDD pmos
M20 n3 GND n5 GND nmos
M21 n0 GND n3 GND nmos
M22 n0 GND n4 GND nmos

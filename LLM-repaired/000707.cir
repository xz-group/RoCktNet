M1 n3 n1 n6 VDD pmos
I1 n5 GND
X1 n7 label_net_1 label_net_0 amplifier
M2 n4 label_net_1 n6 VDD pmos
I2 label_net_2 n6
C1 n2 GND
M3 n8 n7 n5 GND nmos
M4 n4 n4 GND GND nmos
M5 n0 n4 GND GND nmos
M6 label_net_3 n8 n0 GND nmos
M7 n3 n3 GND GND nmos
S1 n1 n2 switch_ideal

M1 N3 N1 N6 VDD pmos
I1 N5 GND
A1 (N7 LABEL_NET_1 LABEL_NET_0) amplifier
M2 N4 LABEL_NET_1 N6 VDD pmos
I2 LABEL_NET_2 N6
C1 N2 GND
M4 N8 N7 N5 GND nmos
M3 N4 N4 GND GND nmos
M5 N0 N4 GND GND nmos
M6 LABEL_NET_3 N8 N0 GND nmos
M7 N3 N3 GND GND nmos
S1 (N1 N2) switch_ideal

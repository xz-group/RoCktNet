I3 VG VS Sig
C1 VG N1 CGS
R1 N1 VS RGS
I2 VD VS gmVgs
I1 VD VS Sid

M1 N3 Inn N0 GND nmos
M2 N0 bias_4 GND GND nmos
M3 Outn bias_3 N7 GND nmos
M4 Outp bias_2 N3 VDD pmos
M5 Outn bias_2 N2 VDD pmos
M6 N3 bias_1 VDD VDD pmos
M7 N2 Inp N0 GND nmos
M8 N10 bias_4 N6 GND nmos
M9 N2 bias_1 VDD VDD pmos
M10 Outp bias_3 N10 GND nmos
M11 N7 bias_4 N6 GND nmos

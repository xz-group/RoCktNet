I1 N0 GND
I2 N1 GND
Q1 OUT2 IN2 N1 npn
Q2 OUT1 IN2X N1 npn
Q3 OUT1 IN1 N0 npn
Q4 OUT2 IN1X N0 npn

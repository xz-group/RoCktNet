M1 n5 label_net_0 GND GND nmos
M2 label_net_1 label_net_2 n2 GND nmos
M3 n4 label_net_3 GND GND nmos
M4 n3 label_net_4 n5 GND nmos
M5 n3 n1 n4 GND nmos
M6 n1 n0 GND GND nmos
M7 n1 label_net_6 label_net_5 GND nmos
M8 n2 label_net_7 GND GND nmos
M9 n2 n0 label_net_8 VDD pmos
M10 n1 n2 label_net_9 VDD pmos

M1 n6 label_net_0 GND GND nmos
D1 GND n5 diode
M2 n3 n7 VDD VDD pmos
M3 n6 n0 VDD VDD pmos
M4 n8 label_net_1 GND GND nmos
M5 n7 n9 GND GND nmos
M6 n3 n9 GND GND nmos
M7 n7 n5 VDD VDD pmos
M8 n6 n6 GND GND nmos
M9 n2 label_net_2 n2 GND nmos
M10 n2 n4 GND GND nmos
M11 n6 n6 VDD VDD pmos
M12 n1 n5 n8 GND nmos
M13 n0 label_net_3 n8 GND nmos
M14 n5 n6 VDD VDD pmos
M15 n4 label_net_4 GND GND nmos
M16 n6 n6 VDD VDD pmos
M17 n4 n6 VDD VDD pmos
M18 n1 n1 n0 VDD pmos
M19 n0 n1 VDD VDD pmos

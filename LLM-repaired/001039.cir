I1 VDD OUT
I2 N3 GND
V1 VDD N0
V2 N7 GND
M1 N2 N2 VDD VDD pmos
M2 N6 N4 VDD VDD pmos
M3 N4 IN- N3 GND nmos
M4 OUT N5 GND GND nmos
M5 N2 IN+ N3 GND nmos
M6 N6 N6 GND GND nmos
M7 N5 N2 N0 VDD pmos
M8 N5 N6 N7 GND nmos
M9 N4 N4 VDD VDD pmos
C1 OUT N5

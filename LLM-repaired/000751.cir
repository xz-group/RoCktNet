M1 n3 n0 n1 n1 pmos
M2 GND label_net_0 GND GND nmos
M3 n3 n3 n4 GND nmos
M4 n2 n0 n1 n1 pmos
M5 n2 label_net_1 n4 GND nmos
M6 n4 label_net_2 n2 VDD pmos

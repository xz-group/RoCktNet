M1 n1 GND VDD VDD pmos
M2 n6 n0 n1 n1 nmos
M3 n4 n0 n1 VDD pmos
M4 n2 n6 n1 VDD pmos
M5 n1 GND VDD VDD pmos
M6 n2 n4 n1 VDD pmos
M7 n5 n1 n1 VDD pmos
M8 n5 label_net_0 n3 GND nmos
M9 n5 n1 n1 VDD pmos
M10 GND label_net_1 n3 VDD pmos
M11 n2 label_net_2 n3 GND nmos

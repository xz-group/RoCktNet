M1 n4 n2 VDD VDD pmos
M2 n1 n0 n5 GND nmos
M3 n4 n8 n5 GND nmos
M4 n2 label_net_0 n4 VDD pmos
M5 n1 n4 VDD VDD pmos
M6 n6 n3 n8 VDD pmos
M7 n0 n3 n6 VDD pmos
M8 n0 label_net_1 n4 GND nmos
M9 n1 label_net_2 n8 GND nmos
M10 n0 n3 n8 GND nmos
M11 n0 label_net_3 n1 GND nmos
M12 n2 label_net_0 n1 GND nmos

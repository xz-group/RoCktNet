M1 a N2 VDD VDD pmos
M7 b BitB SX GND nmos
M5 a Bit SX GND nmos
M3 N2 conaz a VDD pmos
M2 b a VDD VDD pmos
M11 V_BLP blp Bit VDD pmos
M12 BitB blp V_BLP VDD pmos
M9 BitB condprz a GND nmos
M8 b conbprz Bit GND nmos
M10 BitB blp Bit GND nmos
M6 BitB concz b GND nmos
M4 N2 conaz b GND nmos

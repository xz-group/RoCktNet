M13 N1 Vbias3 N3 VDD pmos
M4 N8 Vr_plus N2 GND nmos
M9 N8 Vbias3 N9 VDD pmos
M2 N2 N4 GND GND nmos
M5 N1 Vr_minus N13 GND nmos
M10a N6 N8 VDD VDD pmos
M8 N9 N8 VDD VDD pmos
M12 N3 N1 VDD VDD pmos
M11a to_ACSUs_L Vbias3 N6 VDD pmos
M1 N4 N4 GND GND nmos
Ibm VDD N4
M3 N13 N4 GND GND nmos
M15a to_ACSUs_R Vbias3 N5 VDD pmos
M14a N5 N1 VDD VDD pmos
M7 N2 Vr_minus N13 GND nmos
M6 N13 Vr_plus N2 GND nmos

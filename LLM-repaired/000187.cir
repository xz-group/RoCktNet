M1 n1 n10 n3 VDD pmos
M2 n8 n7 n2 GND nmos
M3 n8 n10 n9 VDD pmos
M4 n2 n4 GND GND nmos
M5 n1 n0 n13 GND nmos
M6 n6 n8 VDD VDD pmos
M7 n9 n8 VDD VDD pmos
M8 n3 n1 VDD VDD pmos
M9 label_net_0 n10 n6 VDD pmos
M10 n4 n4 GND GND nmos
I1 VDD n4
M11 n13 n4 GND GND nmos
M12 label_net_1 n10 n5 VDD pmos
M13 n5 n1 VDD VDD pmos
M14 n2 n0 n13 GND nmos
M15 n13 n7 n2 GND nmos

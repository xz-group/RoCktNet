M1 n3 n1 n2 VDD pmos
M2 n3 n0 GND GND nmos
M3 n1 n0 GND GND nmos
M4 n1 label_net_1 n2 VDD pmos
M5 n3 label_net_2 n2 VDD pmos
M6 n1 n3 n2 VDD pmos

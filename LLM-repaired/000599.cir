M1 VBN VBN GND GND nmos
M2 LABEL_NET_0 VBN LABEL_NET_0 GND nmos
M3 VBN VBP VDD VDD pmos
M4 GND VBP GND VDD pmos

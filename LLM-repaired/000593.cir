M1 N3 B GND GND nmos
M2 Out A N3 GND nmos
M3 Out A VDD VDD pmos
M4 Out B VDD VDD pmos

M1 n1 n1 n3 n3 pmos
M2 n2 label_net_0 GND GND nmos
M3 n0 n1 n3 n3 pmos
M4 n0 n0 n2 GND nmos
M5 n1 label_net_1 n2 GND nmos
M6 n2 label_net_2 n1 VDD pmos

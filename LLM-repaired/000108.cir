M1 n0 label_net_0 GND GND nmos
M2 n0 label_net_1 GND GND nmos
M3 n3 label_net_2 GND GND nmos
M4 n1 label_net_3 GND GND nmos
M5 n2 label_net_4 n0 GND nmos
M6 n1 label_net_5 n3 GND nmos
M7 n2 label_net_6 n1 GND nmos

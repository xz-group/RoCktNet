M1 N4 Vbn GND GND nmos
M2 Vo_minus Vi_plus N1 GND nmos
M3 VDD VDD N4 GND nmos
M4 N1 Vbn GND GND nmos
M5 VDD VDD VDD VDD pmos
M6 Vo_plus Vi_minus N1 GND nmos
M7 Vo_plus Vo_plus VDD VDD pmos
M8 Vo_minus VDD VDD VDD pmos
M9 Vo_plus VDD VDD VDD pmos

Q1 N8 N6 N3 npn
Q2 GND REF N5 npn
R1 N16 GND 50
R2 N17 -3.6V 50
R3 N15 -3.6V 50
Q3 N1 N5 N11 npn
R4 N1 GND 50
R5 N8 GND 50
R6 N20 -3.6V 50
R7 N10 -3.6V 50
R8 N9 -3.6V 50
Q4 GND N1 N7 npn
Q5 N16 N7 N3 npn
R9 REF GND 50
Q6 N0 N12 N11 npn
R10 N19 -3.6V 50
Q7 GND N16 OUT2 npn
R11 IN GND 50
R12 N0 GND 50
Q8 GND N8 OUT1 npn
Q9 GND N0 N6 npn
R13 N14 -3.6V 50
R14 N28 -3.6V 50
Q10 N7 VB N17 npn
Q11 N11 VB N20 npn
Q12 OUT1 VB N9 npn
Q13 OUT2 VB N10 npn
Q14 N3 VB N14 npn
Q15 N6 VB N28 npn
Q16 GND IN N12 npn
Q17 N5 VB N15 npn
Q18 N12 VB N19 npn

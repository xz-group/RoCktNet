M1 N6 clk N5 GND nmos
M2 N3 N6 N5 GND nmos
M3 N3 N6 N4 VDD pmos
M4 N6 clk N4 VDD pmos
M5 in N3 out GND nmos
M6 out N6 in GND nmos

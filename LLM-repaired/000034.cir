M1 n2 n1 n6 GND nmos
M2 n0 label_net_1 VDD VDD pmos
M3 n5 n1 n6 GND nmos
M4 n2 label_net_2 n0 VDD pmos
M5 n4 n1 n6 GND nmos
M6 n3 n1 n6 GND nmos
M7 n3 label_net_3 n0 VDD pmos
M8 n4 n4 VDD VDD pmos
M9 n1 n1 n6 GND nmos
M10 n1 n1 n6 GND nmos
M11 n5 n4 VDD VDD pmos
C1 n5 GND

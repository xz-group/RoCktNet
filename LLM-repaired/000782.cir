V94 VIN VSSA acm=vin
R51 VIN VGS Rs
C25 VGS VO Cgs
I0 VGS VO idc=gm*vgs
R43 VO VSSA RL
C24 VO VSSA CL

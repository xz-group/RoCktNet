M2 IREF_SOURCE IREF_SOURCE VSS VSS pmos
M1 SOURCE IREF_SOURCE VSS VSS pmos
M4 ICP VSOURCE SOURCE VSS pmos
M3 ICP VSINK SINK VDD nmos
M5 IREF_SINK IREF_SINK VDD VDD nmos
M6 SINK IREF_SINK VDD VDD nmos

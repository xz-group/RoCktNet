M1 GND label_net_0 n4 VDD pmos
M2 n2 GND n7 VDD pmos
M3 GND n2 n0 GND nmos
M4 GND label_net_2 n5 VDD pmos
M5 n1 GND n6 VDD pmos
M6 n7 n7 VDD VDD pmos
M7 n3 label_net_3 GND GND nmos
M8 n0 label_net_4 n3 GND nmos
M9 GND n1 n0 GND nmos
M10 n4 GND n2 VDD pmos
M11 n5 GND n1 VDD pmos
M12 n6 label_net_6 VDD VDD pmos

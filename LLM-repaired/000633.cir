I1 N_TAIL GND
I2 OUT_R GND
I3 OUT_L GND
M1 VDD N_L OUT_L GND nmos
M2 VDD N_R OUT_R GND nmos
M3 N_R IN_R N_TAIL GND nmos
M4 N_L IN_L N_TAIL GND nmos
M5 N_R N_R VDD VDD pmos
M6 N_R N_R VDD VDD pmos
M7 N_L N_L VDD VDD pmos
M8 N_L N_L VDD VDD pmos

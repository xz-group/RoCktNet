M3A VOUTP N2 VDD VDD pmos
M4A VOUTP VBIAS GND GND nmos
M2A N2 N2 VDD VDD pmos
M2B N0 N0 VDD VDD pmos
M3B VOUTN N0 VDD VDD pmos
M5 N1 VBIAS GND GND nmos
M1B N0 VINN N1 GND nmos
M1A N2 VINP N1 GND nmos
M4B VOUTN VBIAS GND GND nmos

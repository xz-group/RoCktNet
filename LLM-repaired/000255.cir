M1 NET_T4P_S NET_T4CM_S GND GND nmos
M2 NET_T11_D VB4 GND GND nmos
M3 NET_T4CM_D NET_T4CM_D NET_T4CM_S GND nmos
M4 NET_T4CM_S VCM GND GND nmos
M5 NET_T1_D VB2 NET_T0_D VDD pmos
M6 NET_T11_D NET_T11_D NET_T8P_D VDD pmos
M7 NET_T4_S IN+ NET_T1_D VDD pmos
M8 NET_T5P_S NET_T4CM_D NET_T4P_S GND nmos
M9 OUT- OUT- NET_T7_D VDD pmos
M10 OUT- VB3 NET_T5_S GND nmos
M11 NET_T8P_D NET_T8P_D NET_T9PTOP_D VDD pmos
M12 NET_T4CM_D VB2 NET_T12_D VDD pmos
M13 NET_T9PTOP_D VB2 NET_T10P_D VDD pmos
M14 NET_T10P_D VB1 VDD VDD pmos
M15 NET_T4_S NET_T4CM_S GND GND nmos
M16 NET_T12_D VB1 VDD VDD pmos
M17 OUT+ VB3 NET_T5P_S GND nmos
M18 NET_T7_D NET_T7_D NET_T9TOP_D VDD pmos
M19 NET_T0_D VB1 VDD VDD pmos
M20 NET_T10_D VB1 VDD VDD pmos
M21 NET_T11_D NET_T11_D NET_T8_D VDD pmos
M22 OUT+ OUT+ NET_T7P_D VDD pmos
M23 NET_T5_S NET_T4CM_D NET_T4_S GND nmos
M24 NET_T7P_D NET_T7P_D NET_T9PTOP_D VDD pmos
M25 NET_T8_D NET_T8_D NET_T9TOP_D VDD pmos
M26 NET_T9TOP_D VB2 NET_T10_D VDD pmos
M27 NET_T4P_S IN- NET_T1_D VDD pmos

I1 N0 N7
I2 N3 GND
M1 N1 N1 N0 VDD pmos
M2 N5 N3 GND GND nmos
M3 N0 N6 GND GND nmos
I3 N7 N9
I4 N5 N8
M4 N2 N2 N5 VDD pmos
M5 N5 LABEL_NET_2 N5 GND nmos
M6 N0 LABEL_NET_4 LABEL_NET_3 GND nmos
M7 N2 N10 N3 GND nmos
M8 N1 N9 N6 GND nmos
I5 N8 N10
M9 N5 N2 LABEL_NET_5 VDD pmos
M10 N0 N1 VDD VDD pmos

M1 n3 VDD n4 GND nmos
M2 n3 n3 n2 VDD pmos
M3 n4 label_net_0 GND GND nmos
M4 n3 n3 VDD VDD pmos
M5 n0 n0 n4 GND nmos
M6 n3 n3 n4 GND nmos
M7 n0 VDD n4 GND nmos
M8 n0 n0 n1 VDD pmos
M9 n0 n0 VDD VDD pmos
M10 n3 n0 n2 VDD pmos
M11 n3 n0 n1 VDD pmos

M1 Vcontrol S_minus Vdd VDD pmos
M2 Vcontrol Out_plus Vdd VDD pmos
M3 Vcontrol S_plus Vdd VDD pmos
M4 Vcontrol Out_minus Vdd VDD pmos
M5 Vcontrol p_plus GND GND nmos
M6 Vcontrol p_minus GND GND nmos
M8 Out_plus N1 Vcontrol GND nmos
M7 Out_minus N1 Vcontrol GND nmos

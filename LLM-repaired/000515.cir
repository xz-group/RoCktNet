M1 n0 label_net_0 n2 VDD pmos
M2 n0 n3 n2 VDD pmos
M3 n0 label_net_1 n2 VDD pmos
M4 n0 n4 n2 VDD pmos
M5 n0 label_net_2 GND GND nmos
M6 n0 label_net_3 GND GND nmos
M7 n3 n1 n0 GND nmos
M8 n4 n1 n0 GND nmos

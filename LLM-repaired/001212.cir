M1 n4 label_net_0 GND GND nmos
M2 n5 label_net_1 n1 GND nmos
M3 n4 label_net_2 VDD VDD pmos
M4 n1 n8 GND GND nmos
M5 n10 n4 VDD VDD pmos
M6 GND n3 n0 VDD pmos
M7 n2 n4 VDD VDD pmos
M8 n3 label_net_3 n10 VDD pmos
M9 n3 label_net_4 GND GND nmos
M10 GND n3 n2 VDD pmos
M11 n0 n4 VDD VDD pmos
M12 n5 label_net_6 n5 VDD pmos
C1 n3 GND
M13 n5 n8 GND GND nmos

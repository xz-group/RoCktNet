R12 V1 V2 R12
Icell GND V3 Icell
Iref GND V4 Iref
R2 V3 GND 1/gds
R34 V3 V4 R34
R4 V1 GND Rd
C1 V2 GND Cd
R5 V4 GND 1/gds
R6 V2 GND Rd
C2 V3 GND Cs
C3 V1 GND Cd
C4 V4 GND Cs
IM3 V1 V3 IM3
IM2 V2 GND IM2
IM1 V1 GND IM1
IM4 V2 V4 IM4

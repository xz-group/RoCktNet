R1 V1 V2 R12
I1 GND V3 Icell
I2 GND V4 Iref
R2 V3 GND 1/gds
R3 V3 V4 R34
R4 V1 GND Rd
C1 V2 GND Cd
R5 V4 GND 1/gds
R6 V2 GND Rd
C2 V3 GND Cs
C3 V1 GND Cd
C4 V4 GND Cs
I3 V1 V3 IM3
I4 V2 GND IM2
I5 V1 GND IM1
I6 V2 V4 IM4

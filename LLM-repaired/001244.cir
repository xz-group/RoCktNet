M1 N3 clk GND GND nmos
M2 QB N0 N3 GND nmos
M3 N0 reset GND GND nmos
M4 QB N0 VDD VDD pmos
M5 N0 reset N2 VDD pmos
M6 N2 clk VDD VDD pmos

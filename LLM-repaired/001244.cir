M1 N3 CLK GND GND nmos
M2 QB N0 N3 GND nmos
M3 N0 RESET GND GND nmos
M4 QB N0 VDD VDD pmos
M5 N0 RESET N2 VDD pmos
M6 N2 CLK VDD VDD pmos

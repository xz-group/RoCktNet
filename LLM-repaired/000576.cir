M3 IN_L N2 GND GND nmos
M4 IN_L N2 N3 VDD pmos
M2 N2 IN N3 VDD pmos
M1 N2 IN GND GND nmos
M6 IN_R IN_L N3 VDD pmos
M5 IN_R IN_L GND GND nmos

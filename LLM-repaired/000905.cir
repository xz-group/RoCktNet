M1 n4 n2 n11 GND nmos
M2 n1 n9 n8 GND nmos
M3 n3 n4 GND GND nmos
M4 n9 n2 n12 GND nmos
M5 n3 n0 n5 VDD pmos
M6 n8 n6 n7 GND nmos
M7 n9 n4 GND VDD pmos
M8 n1 n6 n5 VDD pmos
M9 n12 n6 n7 GND nmos
M10 n1 n3 n5 VDD pmos
M11 n13 n1 n5 VDD pmos
M12 n4 n0 n13 VDD pmos
M13 n11 n1 n7 GND nmos
C1 n4 n7

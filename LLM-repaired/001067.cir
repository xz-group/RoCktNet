I1 n0 GND
M1 VDD label_net_0 n0 GND nmos
M2 VDD label_net_3 n0 GND nmos
M3 label_net_4 label_net_4 n0 GND nmos

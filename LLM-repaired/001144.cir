M1 n0 n0 GND GND nmos
M2 n0 n2 n3 VDD pmos
M3 n3 n4 VDD VDD pmos
M4 n5 n5 GND GND nmos
M5 n1 n4 VDD VDD pmos
M6 n0 n2 n1 VDD pmos
M7 n5 label_net_0 n1 VDD pmos
M8 n5 label_net_1 n3 VDD pmos

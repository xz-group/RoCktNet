I1 VDD n0
M1 n1 n0 VDD VDD pmos
M2 n1 label_net_0 GND GND nmos
M3 n1 label_net_1 GND GND nmos
M4 n0 label_net_2 n1 GND nmos
M5 label_net_3 n2 VDD VDD pmos
M6 n2 n0 VDD VDD pmos

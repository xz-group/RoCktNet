M1 n0 n8 n4 GND nmos
M2 n5 n6 n4 GND nmos
M3 n8 label_net_0 n7 VDD pmos
M4 n8 n8 n4 GND nmos
M5 n6 n6 n4 GND nmos
M6 n6 label_net_1 n7 VDD pmos
M7 n5 n3 VDD VDD pmos
M8 n0 n3 VDD VDD pmos
M9 n7 n1 VDD VDD pmos
M10 n0 n2 VDD VDD pmos
M11 n5 n1 VDD VDD pmos

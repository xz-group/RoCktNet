X1 n3 n2 n6 label_net_0 amplifier
X2 n2 label_net_1 n0 amplifier
M1 n4 n3 VDD VDD pmos
M2 n2 GND n3 VDD pmos
M3 n2 label_net_3 n4 VDD pmos
X3 n2 label_net_4 n7 amplifier
M4 n0 GND n1 VDD pmos
M5 label_net_2 n3 VDD VDD pmos
M6 n2 VDD n2 GND nmos
M7 n2 n6 GND GND nmos
M8 n1 n3 VDD VDD pmos
M9 n7 VDD n5 GND nmos
M10 n0 label_net_8 n10 GND nmos
M11 n5 n6 GND GND nmos
M12 n2 label_net_9 n10 GND nmos
M13 n10 n6 GND GND nmos
M14 n4 label_net_10 n7 GND nmos

A1 (N3 OUT N6 LABEL_NET_0) amplifier
A2 (OUT LABEL_NET_1 N0) amplifier
M1 N4 N3 VDD VDD pmos
M2 OUT GND N3 VDD pmos
M3 OUT UP_BAR N4 VDD pmos
A3 (OUT LABEL_NET_4 N7) amplifier
M4 N0 GND N1 VDD pmos
M5 LABEL_NET_2 N3 VDD VDD pmos
M6 OUT VDD OUT GND nmos
M7 OUT N6 GND GND nmos
M8 N1 N3 VDD VDD pmos
M9 N7 VDD N5 GND nmos
M10 N0 DN_BAR N10 GND nmos
M11 N5 N6 GND GND nmos
M12 OUT DN N10 GND nmos
M13 N10 N6 GND GND nmos
M14 N4 UP N7 GND nmos

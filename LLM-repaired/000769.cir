M1 n2 n4 n1 GND nmos
M2 label_net_0 n4 GND GND nmos
M3 n1 label_net_1 GND GND nmos
M4 n2 n3 VDD VDD pmos
M5 n4 n0 GND GND nmos
M6 n0 n2 GND GND nmos
M7 n4 n3 VDD VDD pmos
M8 n0 n3 VDD VDD pmos

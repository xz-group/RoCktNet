M15 out N3 GND GND nmos
M7 N5 in_plus GND GND nmos
M5 in_minus in_plus GND GND nmos
M8 N0 in_minus GND GND nmos
M3 in_minus in_minus GND GND nmos
M13 N3 N5 GND GND nmos
M11 Vb Vb VDD VDD pmos
M10 N5 N0 VDD VDD pmos
M4 in_plus in_plus GND GND nmos
M1 in_minus in_minus Vb VDD pmos
M2 in_plus in_plus Vb VDD pmos
M9 N0 N0 VDD VDD pmos
M6 in_plus in_minus GND GND nmos
M14 out N3 VDD VDD pmos
M12 N3 N5 VDD VDD pmos

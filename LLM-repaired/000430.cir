I1 VDD n7
I2 VDD n1
I3 VDD n4
M1 n1 n1 GND GND nmos
M2 n2 n2 GND GND nmos
M3 n2 label_net_0 VDD VDD pmos
M4 n8 n5 VDD VDD pmos
M5 n0 n1 n7 VDD pmos
M6 n3 n9 n4 VDD pmos
M7 n5 n5 VDD VDD pmos
M8 n0 n2 n4 VDD pmos
M9 n6 n8 n7 VDD pmos
M10 n6 n1 n4 VDD pmos
M11 n8 n8 n10 GND nmos
M12 n5 label_net_1 n10 GND nmos
M13 n3 n8 n7 VDD pmos

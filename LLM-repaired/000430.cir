I_SS1_2 VDD N7
I_SS2 VDD V_VR
I_SS1 VDD N4
M13 V_VR V_VR GND GND nmos
M8 V_VP V_VP GND GND nmos
M7 V_VP V_GP VDD VDD pmos
M11 V_VN N5 VDD VDD pmos
M6 I_X V_VR N7 VDD pmos
M2 I_Z N9 N4 VDD pmos
M10 N5 N5 VDD VDD pmos
M1 I_X V_VP N4 VDD pmos
M4 I_Y V_VN N7 VDD pmos
M3 I_Y V_VR N4 VDD pmos
M12 V_VN V_VN V_SS GND nmos
M9 N5 V_GN V_SS GND nmos
M5 I_Z V_VN N7 VDD pmos

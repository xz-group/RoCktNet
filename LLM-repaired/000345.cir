M1 VX N1 VSS VSS nmos
M2 N1 N1 VSS VSS nmos
M3 VOUT- VZ VSS VSS nmos
M4 VX VX VDD VDD pmos
M5 VZ VZ VSS VSS nmos
M6 VZ V1- VDD VDD pmos
M7 VOUT- VX VDD VDD pmos
M8 N1 V1+ VDD VDD pmos
M9 VX VX VDD VDD pmos
M10 VOUT+ N1 VSS VSS nmos
M11 VOUT+ VX VDD VDD pmos
M12 VX VZ VSS VSS nmos

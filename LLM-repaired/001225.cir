I1 n3 n0
I2 n7 n2
I3 n1 n2
I4 n5 n2
I5 n6 n2
M1 n4 n4 n3 VDD pmos
M2 n4 n8 n1 GND nmos
M3 n9 n8 n7 GND nmos
M4 n9 n4 n3 VDD pmos
M5 n7 n2 n0 VDD pmos
M6 n1 n2 n0 VDD pmos
Q1 n3 label_net_0 n6 npn
M7 n3 label_net_1 n5 GND nmos

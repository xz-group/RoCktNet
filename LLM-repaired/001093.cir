I1 N8 GND
M1 N12 N4 VDD VDD pmos
I2 N4 GND
I3 N1 GND
I4 N10 GND
M2 N0 N1 VDD VDD pmos
M3 N6 LABEL_NET_0 N7 VDD pmos
M4 VDD VDD N3 VDD pmos
M5 N7 N7 GND GND nmos
M6 N9 N7 GND GND nmos
M7 N11 N11 GND GND nmos
M8 N4 VDD N12 VDD pmos
M9 VDD N11 GND GND nmos
M10 N6 N10 VDD VDD pmos
M11 N9 N9 VDD VDD pmos
M12 N1 N9 N0 VDD pmos
M13 N7 LABEL_NET_1 N0 VDD pmos
M14 N2 VDD N5 VDD pmos
M15 N11 N9 N3 VDD pmos
M16 N10 N10 N6 VDD pmos
M17 N5 N2 VDD VDD pmos
M18 N8 N2 N5 VDD pmos
C1 N9 GND
M19 N9 VDD N0 VDD pmos
C2 VDD GND

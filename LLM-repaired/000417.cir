M1 TX ON GND GND nmos
R1 TX GND Ron
R2 AN GND 50
C1 AN TX Coff
M2 TX OFF AN GND nmos

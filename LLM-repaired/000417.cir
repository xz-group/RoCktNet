M1 Tx ON GND GND nmos
R1 Tx GND Ron
R2 An GND 50
C1 An Tx Coff
M2 Tx OFF An GND nmos

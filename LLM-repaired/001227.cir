I1 IN GND
M1 OUT IN VDD VDD pmos
M2 OUT IN VDD VDD pmos
M3 IN IN VDD VDD pmos
M4 OUT IN VDD VDD pmos
M5 OUT IN VDD VDD pmos
M6 IN IN VDD VDD pmos

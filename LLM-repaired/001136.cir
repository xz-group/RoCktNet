M2 OUT ctrl1 N1 GND nmos
M1 N1 P2 GND GND nmos
M4 OUT ctrl2 N2 GND nmos
M3 N2 P3 GND GND nmos
M7 OUT ctrl3 N3 GND nmos
M5 N3 P4 GND GND nmos
M8 OUT ctrl4 N4 GND nmos
M6 N4 P5 GND GND nmos
M9 OUT GND VDD VDD pmos

R1 VDD VOUT1
R2 VDD VOUT2
M1 N_M1D VIN+ GND GND nmos
M2 N_M2D VIN- GND GND nmos
M3 VOUT1 VLO+ N_M1D GND nmos
M4 VOUT2 VLO- N_M1D GND nmos
M5 VOUT1 VLO- N_M2D GND nmos
M6 VOUT2 VLO+ N_M2D GND nmos
M1A N_M1AD VIN+ GND GND nmos
M2A N_M2AD VIN- GND GND nmos
M3A N_GC1 VLO- N_M1AD GND nmos
M4A N_GC2 VLO+ N_M1AD GND nmos
M5A N_GC1 VLO+ N_M2AD GND nmos
M6A N_GC2 VLO- N_M2AD GND nmos
M7 VOUT1 VG+ N_GC1 GND nmos
M8 VOUT2 VG- N_GC1 GND nmos
M9 VOUT1 VG+ N_GC2 GND nmos
M10 VOUT2 VG- N_GC2 GND nmos

MS3 out_minus Vcm_ctrl VDD VDD pmos
M2 out_plus in_minus N0 GND nmos
M3 N0 LABEL_NET_1 GND GND nmos
M4 out_minus in_plus N0 GND nmos
MS4 out_plus Vcm_ctrl VDD VDD pmos

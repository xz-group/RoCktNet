M1 n0 n3 label_net_0 VDD pmos
M2 n2 n3 label_net_1 VDD pmos
M3 n2 n2 label_net_2 VDD pmos
M4 n0 label_net_3 n1 GND nmos
M5 n1 label_net_4 GND GND nmos
M6 n2 label_net_5 n1 GND nmos
M7 n0 n0 label_net_6 VDD pmos

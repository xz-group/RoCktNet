R1 n0 n8
M1 n0 label_net_0 n4 GND nmos
Q1 n1 label_net_1 n2 npn
R2 n0 n3
M2 n0 label_net_2 n4 GND nmos
Q2 n6 label_net_3 n8 npn
Q3 n5 label_net_4 n2 npn
Q4 n1 label_net_5 n6 npn
Q5 n2 label_net_6 n3 npn
M3 n1 label_net_7 n7 VDD pmos
Q6 n5 label_net_8 n6 npn
M4 n5 label_net_9 n7 VDD pmos

P0 (Stack_node A VCC Body_A) pmos
M1 Out B Stack_node Body_B pmos
M3 Out A GND GND nmos
M4 Out B GND GND nmos

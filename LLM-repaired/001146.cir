M2 STACK_NODE A VCC BODY-A pmos
M1 OUT B STACK_NODE BODY-B pmos
M3 OUT A GND GND nmos
M4 OUT B GND GND nmos

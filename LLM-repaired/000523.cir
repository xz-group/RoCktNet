M1 n0 n1 VDD VDD pmos
M2 n1 n0 VDD VDD pmos
M3 n3 label_net_0 VDD VDD pmos
M4 n1 n0 GND GND nmos
M5 n0 n1 GND GND nmos
M6 n2 label_net_1 VDD VDD pmos
M7 n4 n3 VDD VDD pmos
M8 n4 n3 GND GND nmos
M9 n2 VDD n1 GND nmos
M10 n3 VDD n2 GND nmos

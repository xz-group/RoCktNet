IB TAIL GND IB
L1 VDD N1 LD
L2 VDD N2 LD
R1 N1 VOUT- RD
R2 N2 VOUT+ RD
M1 VOUT- VIN+ TAIL GND nmos
M2 VOUT+ VIN- TAIL GND nmos
M3 VOUT- VOFFSET+ TAIL GND nmos
M4 VOUT+ VOFFSET- TAIL GND nmos

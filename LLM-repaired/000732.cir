M3 Ve Ii VSS GND nmos
M4 Ve Ii VDD VDD pmos
M2 VDD Ve Ii GND nmos
M1 VSS Ve Ii VDD pmos

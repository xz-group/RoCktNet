X1 n1 n3 n0 amplifier
M1 n2 GND label_net_0 VDD pmos
M2 GND n4 n0 VDD pmos
M3 n1 label_net_1 n1 GND nmos
M4 GND n3 GND GND nmos
M5 n1 GND n1 GND nmos
M6 GND GND n2 VDD pmos
M7 n2 n3 GND GND nmos
M8 n0 GND n1 VDD pmos
M9 GND label_net_2 n0 VDD pmos
M10 GND VDD n2 VDD pmos

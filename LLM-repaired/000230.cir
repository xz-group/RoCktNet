A1 (V_prime N3 N0) amplifier
M1 N2 GND V VDD pmos
M2 GND N4 N0 VDD pmos
M3 V_prime dn V_prime GND nmos
M4 GND N3 GND GND nmos
M5 V_prime GND V_prime GND nmos
M10 GND GND N2 VDD pmos
M7 N2 N3 GND GND nmos
M8 N0 GND V_prime VDD pmos
M9 GND Vctrl N0 VDD pmos
M6 GND VDD N2 VDD pmos

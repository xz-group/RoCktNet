I1 n4 n3
M1 n6 label_net_0 n8 n8 nmos
I2 n4 n2
M2 n3 n9 n5 n5 nmos
M3 n10 n10 n8 n8 nmos
M4 n7 n7 n8 n8 nmos
X1 label_net_3 label_net_4 n0 amplifier
M5 n5 n5 n8 n8 nmos
M6 n10 n1 n4 n4 pmos
M7 n4 n9 n6 n6 nmos
M8 n2 n1 n7 n7 nmos
M9 n6 n0 n10 n10 nmos

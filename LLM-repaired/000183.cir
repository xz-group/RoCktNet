I1 N4 N3
M7 N6 In N8 N8 nmos
I2 N4 N2
M6 N3 N9 N5 N5 nmos
M3 Out Out N8 N8 nmos
M4 N7 N7 N8 N8 nmos
X1 (Const BLD_Output sw) amplifier
M5 N5 N5 N8 N8 nmos
M2 Out N1 N4 N4 pmos
M1 N4 N9 N6 N6 nmos
M8 N2 N1 N7 N7 nmos
M9 N6 sw Out Out nmos

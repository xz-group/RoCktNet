M1 nbias N1 nbias GND nmos
M2 nbias N2 nbias GND nmos
M3 N1 nbias N8 GND nmos
M4 nbias N6 N5 GND nmos
M5 N0 LABEL_NET_0 N0 VDD pmos
M6 pbias pbias LABEL_NET_0 VDD pmos
M7 pcas pcas pbias VDD pmos
M8 pbias nbias N2 VDD pmos
M9 N0 nbias N2 VDD pmos
M10 N2 nbias LABEL_NET_2 VDD pmos
M11 nbias nbias N8 GND nmos
M12 N8 nbias LABEL_NET_3 GND nmos
M13 N2 pcas N2 VDD pmos
M14 LABEL_NET_2 nbias LABEL_NET_4 VDD pmos
M15 N1 N1 N1 GND nmos
M16 N6 nbias nbias nbias nmos
M17 nbias nbias N5 VDD pmos

I1 n2 GND
I2 n4 GND
M1 VDD VDD n3 GND nmos
M2 n0 n5 n2 GND nmos
M3 VDD VDD n0 GND nmos
M4 n3 label_net_0 n4 GND nmos
M5 VDD VDD n1 GND nmos
M6 VDD VDD n1 GND nmos
M7 n1 n1 n2 GND nmos
M8 n1 n5 n4 GND nmos

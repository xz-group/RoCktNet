M1 n0 label_net_0 n2 n2 nmos
M2 n0 GND VDD VDD pmos
M3 n1 GND VDD VDD pmos
M4 n1 label_net_1 n2 n2 nmos
M5 n2 label_net_2 GND GND nmos

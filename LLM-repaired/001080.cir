MN1 Q_bar D NC NC nmos
M2 Q_bar GND VDD VDD pmos
M3 Q GND VDD VDD pmos
MN2 Q D_bar NC NC nmos
MC1 NC VLOAD GND GND nmos

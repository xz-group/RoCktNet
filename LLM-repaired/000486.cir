M1 N3 vrefp N5 GND nmos
M2 N3 N3 VDD VDD pmos
M3 N1 vrefn N5 GND nmos
M4 N6 compbd VDD VDD pmos
M5 N4 N2 GND GND nmos
M6 N4 N2 N6 VDD pmos
M7 N2 N1 VDD VDD pmos
M8 N1 vinp N0 GND nmos
M9 N2 N4 GND GND nmos
M10 N5 bias GND GND nmos
M11 N0 bias GND GND nmos
M12 N3 vinn N0 GND nmos
M13 N2 N4 N6 VDD pmos
M14 N1 N1 VDD VDD pmos
M15 N4 N3 VDD VDD pmos
M16 N4 compb N2 GND nmos

M1 n2 n3 GND GND nmos
M2 n4 n0 GND GND nmos
M3 n1 label_net_0 n3 GND nmos
M4 n5 n0 n1 VDD pmos
M5 n3 n4 GND GND nmos
M6 n2 n1 label_net_2 VDD pmos
M7 n1 n5 n2 VDD pmos
M8 n1 label_net_4 n4 GND nmos

MRP N6 VT_P N9 VDD pmos
M2_R OUTP VIN N6 VDD pmos
M1_R OUTP VIN N5 VSS nmos
M1_L OUTN VIP N2 VSS nmos
MNB_L N2 VCMFB VSS VSS nmos
M2_L OUTN VIP N9 VDD pmos
MPB_L N9 VB2 VDD VDD pmos
MNB_R N5 VCMFB VSS VSS nmos
MRN_R VCM VT_N N5 VSS nmos
MPB_R N6 VB2 VDD VDD pmos
MRN_L VCM VT_N N2 VSS nmos

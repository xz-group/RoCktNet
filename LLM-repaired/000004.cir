M1 n8 label_net_0 GND GND nmos
M2 n8 n5 GND GND nmos
M3 n7 n4 GND GND nmos
M4 n4 n3 n8 GND nmos
M5 n7 n0 GND GND nmos
M6 n5 n1 n7 GND nmos
M7 n5 n0 n2 VDD pmos
M8 n6 n5 n6 VDD pmos
M9 n2 n1 n5 VDD pmos
M10 n4 label_net_2 n6 VDD pmos
M11 n6 n3 n6 VDD pmos
M12 n4 n3 VDD VDD pmos
M13 n2 n4 n5 VDD pmos
M14 n5 n1 VDD VDD pmos

M1 N1 VIN_P X X nmos
M2 N1 VIN_N X X nmos
M3 N2 VIN_P X X nmos
M4 N2 VIN_N X X nmos
M5 IM5 VIN_P N1 N1 nmos
M6 IM6 VIN_N N2 N2 nmos
M7 X VGM GND GND nmos

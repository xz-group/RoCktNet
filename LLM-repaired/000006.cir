I1 n1 n0
M1 n0 label_net_0 GND GND nmos
M2 n0 label_net_1 GND GND nmos
M3 n1 n1 n0 GND nmos
M4 n0 label_net_2 GND GND nmos
M5 n0 label_net_3 GND GND nmos

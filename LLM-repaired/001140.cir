I1 GND V iph
I2 GND V1 in
I3 V1 GND V*gm_N1
R1 V1 GND go
I4 IOUT V (V1-V)*gm_N2
R2 V GND gi
C1 V V1 Cf
C2 V1 GND Co
C3 V GND Ci

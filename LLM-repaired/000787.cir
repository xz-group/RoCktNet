M0 N_TAIL VB1 VDD VDD pmos
M1 N_FOLD1 VIP N_TAIL VDD pmos
M2 N_FOLD2 VIN N_TAIL VDD pmos
M3 N_FOLD1 N_FOLD1 GND GND nmos
M4 N_FOLD2 N_FOLD1 GND GND nmos
M5 N_FOLD1 N_FOLD1 GND GND nmos
M6 N_FOLD2 N_FOLD1 GND GND nmos
M7 N_CASC1 VB2 N_FOLD1 GND nmos
M8 N_CASC2 VB2 N_FOLD2 GND nmos
M9 N_CASC1 VB1 VDD VDD pmos
M10 N_CASC2 VB1 VDD VDD pmos
M11 VOUT N_CASC2 GND GND nmos
M12 VOUT VB1 VDD VDD pmos
Cc N_CASC2 VOUT

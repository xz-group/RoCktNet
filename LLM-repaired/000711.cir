I1 n5 GND
M1 n0 label_net_0 n5 GND nmos
I2 n3 GND
I3 n4 GND
M2 n2 n3 n5 GND nmos
M3 VDD n1 n3 GND nmos
M4 VDD n1 n4 GND nmos
M5 n0 n0 VDD VDD pmos
M6 n2 n0 VDD VDD pmos
M7 n1 label_net_1 VDD VDD pmos
C1 VDD n1
D1 n1 n2 diode

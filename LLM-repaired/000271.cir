I1 n3 GND
I2 n0 GND
M1 n2 n1 label_net_0 VDD pmos
M2 n1 label_net_1 n3 GND nmos
M3 n1 n1 n2 VDD pmos
M4 n1 label_net_3 n0 GND nmos
M5 n2 label_net_4 n0 GND nmos
M6 n2 label_net_5 n3 GND nmos

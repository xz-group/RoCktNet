M1 Vout_minus Vref_plus N1 GND nmos
M2 Vout_minus Vout_minus VDD VDD pmos
M3 Vout_minus Vin_plus N1 GND nmos
M4 Vout_minus Vout_minus VDD VDD pmos
M5 Vout_minus Vin_minus N2 GND nmos
M6 N1 BIAS GND GND nmos
M7 Vout_minus Vref_minus N2 GND nmos
M8 N2 BIAS GND GND nmos
Msw Vout_minus CLK Vout_minus GND nmos

M1 n0 label_net_0 n1 GND nmos
M2 n0 n0 n3 VDD pmos
M3 n0 label_net_1 n1 GND nmos
M4 n0 n0 n3 VDD pmos
M5 n0 label_net_2 n2 GND nmos
M6 n1 n4 GND GND nmos
M7 n0 label_net_4 n2 GND nmos
M8 n2 n4 GND GND nmos
M9 n0 label_net_5 n0 GND nmos

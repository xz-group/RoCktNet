M1 n5 n5 n0 VDD pmos
M2 n3 n1 n4 GND nmos
M3 n0 n0 VDD VDD pmos
M4 n5 n5 GND GND nmos
M5 n2 n0 VDD VDD pmos
M6 n4 n5 GND GND nmos
M7 n3 n1 n2 VDD pmos

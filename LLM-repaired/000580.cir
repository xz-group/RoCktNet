M1 V1 V2 N_TAIL GND nmos
M2 V1 V2 VDD VDD pmos
M3 V2 V1 N_TAIL GND nmos
M4 V2 V1 VDD VDD pmos
M5 N_TAIL EN GND GND nmos
M6 V1 EN VDD VDD pmos
M7 V2 EN VDD VDD pmos

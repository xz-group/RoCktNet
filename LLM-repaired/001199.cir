I1 VDD n4
I2 n3 n9
M1 n6 n5 n2 VDD pmos
M2 n7 n1 n9 GND nmos
M3 n7 n8 VDD VDD pmos
M4 n0 label_net_0 n3 GND nmos
M5 n2 n5 n2 GND nmos
M6 n6 n8 n7 GND nmos
M7 n1 n1 n9 GND nmos
M8 n2 n0 VDD VDD pmos
M9 n1 label_net_1 n4 VDD pmos

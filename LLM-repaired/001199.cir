Ipump VDD N4
Icharge N3 N9
M3 Vc U P VDD pmos
M6 N N1 N9 GND nmos
M2 N D_bar VDD VDD pmos
M9 M7 U_bar N3 GND nmos
M1 P U P GND nmos
M4 Vc D_bar N GND nmos
M8 N1 N1 N9 GND nmos
M5 P M7 VDD VDD pmos
M10 N1 D N4 VDD pmos

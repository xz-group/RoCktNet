M1 n2 n0 n1 GND nmos
M2 n1 n1 GND GND nmos
M3 n2 n0 label_net_0 VDD pmos
M4 n0 n1 GND GND nmos

M1 N4 Inp N5 VDD pmos
M2 N18 bias4 N2 VDD pmos
M3 N19 N0 VDD VDD pmos
M4 OUT N1 N19 VDD pmos
M5 N1 N13 VDD VDD pmos
M6 N0 N18 VDD VDD pmos
M7 N12 N0 VSS VSS nmos
M8 N3 bias3 N4 VSS nmos
M9 N2 Inn N8 VSS nmos
M10 N7 bias2 VSS VSS nmos
M11 N13 bias3 N7 VSS nmos
M12 N3 N3 VDD VDD pmos
M13 N5 bias1 VDD VDD pmos
M14 N14 N14 VSS VSS nmos
M15 N14 bias4 N15 VDD pmos
M16 N4 bias2 VSS VSS nmos
M17 OUT N1 N12 VSS nmos
M18 N15 Inp N8 VSS nmos
M19 N0 N18 VSS VSS nmos
M20 N13 N3 VDD VDD pmos
M21 N18 N14 VSS VSS nmos
M22 N2 bias1 VDD VDD pmos
M23 N7 Inn N5 VDD pmos
M24 N8 bias2 VSS VSS nmos
M25 N1 N13 VSS VSS nmos
M26 N15 bias1 VDD VDD pmos
Cc OUT N0

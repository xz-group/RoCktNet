I1 VDD n3
I2 VDD GND
I3 VDD n1
I4 VDD n2
M1 n0 n0 n1 VDD pmos
M2 n2 n2 GND GND nmos
D1 n2 GND diode
M3 GND n2 n1 VDD pmos
M4 n2 n2 n3 VDD pmos
M5 GND GND n3 VDD pmos
M6 n0 n2 GND GND nmos

M1 VDD SR_b VDD VDD pmos
M2 IC N5 N3 VDD pmos
M3 VDD N3 VDD VDD pmos
M4 N0 LSA GND GND nmos
M5 N2 RS1 GND GND nmos
M6 C3 N11 VDD VDD pmos
M7 IC N7 N0 GND nmos
M8 C3 N6 GND GND nmos
M9 VDD RS0 SR_b GND nmos
M10 N2 BCN N2 GND nmos
M11 VDD IC T1 GND nmos
M12 N6 IT GND GND nmos
M13 QC VDD GND GND nmos
M14 VDD VDD N3 GND nmos
M15 IC VDD GND GND nmos
M16 QT C3 GND GND nmos
M17 IT VDD N0 GND nmos
M18 N7 SR_b VDD VDD pmos
M19 IT N7 GND GND nmos
M20 VDD BTN N2 GND nmos
M21 RS0 BC RS0 VDD pmos
M22 IT N5 N11 VDD pmos
M23 N11 N11 N6 VDD pmos
M24 RS0 BT VDD VDD pmos

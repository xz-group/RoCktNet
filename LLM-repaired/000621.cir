M1 VDD n10 VDD VDD pmos
M2 n4 n5 n3 VDD pmos
M3 VDD n3 VDD VDD pmos
M4 n0 label_net_0 GND GND nmos
M5 n2 label_net_1 GND GND nmos
M6 n9 n11 VDD VDD pmos
M7 n4 n7 n0 GND nmos
M8 n9 n6 GND GND nmos
M9 VDD n1 n10 GND nmos
M10 n2 label_net_2 n2 GND nmos
M11 VDD n4 label_net_3 GND nmos
M12 n6 n8 GND GND nmos
M13 label_net_4 VDD GND GND nmos
M14 VDD VDD n3 GND nmos
M15 n4 VDD GND GND nmos
M16 label_net_5 n9 GND GND nmos
M17 n8 VDD n0 GND nmos
M18 n7 n10 VDD VDD pmos
M19 n8 n7 GND GND nmos
M20 VDD label_net_7 n2 GND nmos
M21 n1 label_net_8 n1 VDD pmos
M22 n8 n5 n11 VDD pmos
M23 n11 n11 n6 VDD pmos
M24 n1 label_net_9 VDD VDD pmos

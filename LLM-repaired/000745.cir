IC BL GND
IREF OUT1 GND
M1 BL BL GND GND nmos
M2 OUT1 BL GND GND nmos
M3 N2 VREF GND GND nmos
M4 N2 N2 VDD VDD pmos
M5 BL N2 VDD VDD pmos
M6 OUT1 N2 VDD VDD pmos

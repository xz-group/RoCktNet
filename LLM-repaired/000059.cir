I1 n0 GND
I2 VDD VDD
M1 VDD label_net_0 n1 GND nmos
I3 n1 GND
M2 VDD label_net_1 n0 GND nmos
M3 n2 n3 n1 GND nmos
M4 n2 n3 n0 GND nmos
M5 VDD label_net_2 n1 GND nmos
M6 VDD label_net_3 n0 GND nmos
M7 n2 n2 VDD VDD pmos
R1 VDD GND
M8 VDD n2 VDD VDD pmos

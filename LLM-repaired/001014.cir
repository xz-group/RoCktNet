M1 N3 inp N1 GND nmos
M2 N1 clk GND GND nmos
M3 N2 clk GND GND nmos
M4 N4 inn N2 GND nmos
M5 VDD N4 N3 GND nmos
M6 VDD N3 N4 GND nmos

M1 n0 n1 VDD VDD pmos
M2 n1 n0 VDD VDD pmos
M3 n0 n1 GND GND nmos
M4 n1 n0 GND GND nmos
M5 n0 n2 label_net_1 GND nmos
M6 label_net_2 n2 n1 GND nmos

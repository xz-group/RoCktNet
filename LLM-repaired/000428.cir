IS N1 GND
M2 N0 N0 VDD VDD pmos
M3 GND N0 VDD VDD pmos
Q1 N0 VIN_PLUS N1 npn
Q2 GND VIN_MINUS N1 npn

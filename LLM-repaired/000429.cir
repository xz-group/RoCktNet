IS VDD N1
M3 N0 N0 VSS GND nmos
M2 GND Vin_minus N1 VDD pmos
M4 GND N0 VSS GND nmos
M1 N0 Vin_plus N1 VDD pmos

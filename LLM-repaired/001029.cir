I1 VDD N_BIAS
M1 CP_OUTPUT N_PMIRROR VDD VDD pmos
M3 N_PMIRROR N_PMIRROR VDD VDD pmos
M2 CP_OUTPUT N_BIAS N_SW2 GND nmos
M4 N_BIAS N_BIAS N_SRC1 GND nmos
M5 N_SRC1 VDD GND GND nmos
M8 N_PMIRROR N_BIAS N_SW1 GND nmos
M6 N_SW1 UP_BAR GND GND nmos
M7 N_SW2 DOWN_BAR GND GND nmos

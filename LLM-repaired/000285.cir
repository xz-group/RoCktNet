M1 N1 IN_MINUS N4 VDD pmos
M2 N1 N2 N0 GND nmos
M3 N1 N3 OUT_MINUS VDD pmos
M4 N1 N4 OUT_PLUS VDD pmos
M5 N1 N1 N5 GND nmos
M6 N2 IN_PLUS N3 VDD pmos
M7 N0 N1 GND GND nmos
M8 N1 N1 N7 GND nmos
M9 N5 N1 GND GND nmos
M10 N2 N1 N6 GND nmos
M11 N7 N2 GND GND nmos
M12 N6 N1 GND GND nmos

M1 N1 VDD N2 GND nmos
A1 (Vbp N1 Vref) amplifier
M2 N1 N1 VDD VDD pmos
M3 N3 Vn2 GND GND nmos
M4 N1 Vbp VDD VDD pmos
M5 N2 Vn1 N3 GND nmos

M1 n1 VDD n2 GND nmos
X1 n0 n1 label_net_0 amplifier
M2 n1 n1 VDD VDD pmos
M3 n3 label_net_1 GND GND nmos
M4 n1 n0 VDD VDD pmos
M5 n2 label_net_2 n3 GND nmos

I1 n1 GND
M1 n4 n4 GND GND nmos
M2 n3 label_net_0 GND GND nmos
M3 n2 n4 GND GND nmos
M4 n2 n2 GND GND nmos
M5 GND n3 n0 VDD pmos
M6 n2 n5 VDD VDD pmos
M7 n4 n3 n0 VDD pmos
M8 n2 n1 VDD VDD pmos
M9 n5 n5 VDD VDD pmos
M10 n0 label_net_1 VDD VDD pmos
M11 VDD n3 n3 GND nmos
M12 n1 n1 VDD VDD pmos
M13 n5 n3 n3 GND nmos

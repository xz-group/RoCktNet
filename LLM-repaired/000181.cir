R1 VSLD N1
R2 N4 GND
Q1 N1 Vref1 N2 npn
Q2 N3 Vref2 N4 npn
Q3 GND IN N2 pnp
Q4 VSLD IN N3 npn
Q5 N5 N2 OUT npn
Q6 N6 N3 OUT pnp
Q7 N5 N5 VSLD pnp
Q8 OUT N5 VSLD pnp
Q9 N6 N6 GND npn
Q10 OUT N6 GND npn

M1 n5 n4 n0 GND nmos
M2 n3 n1 VDD VDD pmos
M3 n0 n2 VDD VDD pmos
M4 n0 label_net_1 VDD VDD pmos
M5 n3 n5 VDD VDD pmos
M6 n0 n6 VDD VDD pmos
M7 n2 n4 n3 GND nmos
M8 n3 label_net_3 VDD VDD pmos
M9 n3 label_net_4 GND GND nmos
M10 n1 label_net_5 n0 GND nmos
M11 n0 label_net_6 GND GND nmos
M12 n6 label_net_7 n3 GND nmos

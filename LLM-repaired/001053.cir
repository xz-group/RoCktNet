M1 n3 n7 GND GND nmos
M2 n0 n3 VDD VDD pmos
M3 n6 label_net_0 n4 GND nmos
M4 n1 label_net_2 n4 GND nmos
M5 n0 n3 GND GND nmos
M6 n1 n3 n6 GND nmos
M7 n1 n5 n1 GND nmos
M8 n3 n7 VDD VDD pmos
M9 n3 n2 n3 GND nmos
M10 n5 n2 n1 GND nmos

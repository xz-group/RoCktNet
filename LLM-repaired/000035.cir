M1 n0 n7 n6 VDD pmos
M2 n7 n7 n6 VDD pmos
M3 n8 n1 n0 VDD pmos
I1 n7 GND
M4 n11 n4 n8 VDD pmos
M5 n9 n2 n0 VDD pmos
M6 n11 n3 n1 GND nmos
M7 n5 n2 n5 GND nmos
M8 n10 n3 n5 GND nmos
M9 n1 n1 n5 GND nmos
M10 n10 n4 n9 VDD pmos
M11 n5 label_net_0 GND GND nmos

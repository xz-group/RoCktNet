M1 n8 n5 n2 VDD pmos
M2 n4 n10 n8 VDD pmos
M3 n0 n3 GND GND nmos
M4 n4 n1 n7 GND nmos
M5 n5 n1 n4 GND nmos
M6 label_net_0 label_net_1 n6 GND nmos
M7 n0 n3 n2 VDD pmos
M8 n9 n4 n0 VDD pmos
M9 n9 n4 n6 GND nmos
C1 n0 GND
M10 n4 n10 n5 GND nmos
M11 n7 n5 label_net_0 GND nmos

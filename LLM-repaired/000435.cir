R2 N1 OUTP RL
R1 N1 OUTN RL
R3 N1 GND Rcm
M1 OUTP DCAP N3 VSS nmos
M2 OUTP DINN N2 VSS nmos
M3 N2 VOA VSS VSS nmos
M4 N3 VSS VSS VSS nmos
M5 OUTN DINP N2 VSS nmos
M6 OUTN DCAN N3 VSS nmos

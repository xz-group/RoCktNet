M1 OUT IN VDD VDD pmos
M2 N0 N0 VSS VSS nmos
M3 OUT N0 VSS VSS nmos
M4 N0 IN VDD VDD pmos

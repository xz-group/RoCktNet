M1 n0 n4 GND GND nmos
M2 n7 n5 n2 VDD pmos
M3 n8 n7 n2 VDD pmos
M4 n5 n8 n2 VDD pmos
M5 n4 n3 n5 GND nmos
M6 n3 n0 n3 GND nmos
M7 n0 n1 n7 VDD pmos
M8 n3 n5 n8 VDD pmos
M9 n5 n1 n5 VDD pmos
M10 n7 label_net_0 n0 GND nmos

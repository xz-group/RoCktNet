M1 n2 n10 VDD VDD pmos
M2 n12 n8 n6 GND nmos
M3 n3 n2 VDD VDD pmos
M4 n4 n5 n7 GND nmos
M5 n2 n7 n4 GND nmos
M6 n2 n2 label_net_0 VDD pmos
M7 n1 n7 n0 GND nmos
M8 n3 n9 n12 GND nmos
M9 n2 n9 n11 GND nmos
M10 n11 n8 n9 GND nmos
M11 n1 n2 VDD VDD pmos
M12 n2 n10 VDD VDD pmos
C1 n2 GND
M13 n0 n5 n6 GND nmos
M14 n2 n2 VDD VDD pmos

V1 VS GND DC
R1 VS RF_IN Rs
R2 RF_IN GND Rp_ESD
R3 RF_IN GND Rs_prime

A1 (IN- IN+ OP OM) amplifier
C1 IN- OP CiB
C2 IN+ OM CiB
C3 IN- IN1 CiA
C4 IN+ IN2 CiA

M1 GND n8 GND GND nmos
M2 n2 n2 n3 GND nmos
M3 n0 n6 VDD VDD pmos
M4 n8 label_net_0 n12 VDD pmos
M5 VDD n9 VDD VDD pmos
M6 n1 n3 GND GND nmos
M7 n8 label_net_1 n7 VDD pmos
M8 GND n8 GND GND nmos
M9 n8 n8 n3 GND nmos
M10 n6 n0 label_net_2 VDD pmos
M11 n4 n0 n6 VDD pmos
M12 label_net_2 n6 VDD VDD pmos
M13 GND n5 GND GND nmos
M14 n3 n8 n8 GND nmos
M15 n1 n4 VDD VDD pmos
M16 n10 n9 VDD VDD pmos
M17 n5 n5 n6 GND nmos
M18 n11 n10 VDD VDD pmos
M19 GND n5 GND GND nmos
M20 n12 n10 n9 VDD pmos
M21 n5 label_net_4 n11 n7 pmos
M22 n5 label_net_5 n12 VDD pmos
M23 n6 n5 n6 GND nmos
M24 n2 n2 n4 VDD pmos
M25 n2 n1 n2 VDD pmos

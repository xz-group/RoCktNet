M1 VO- VI+ N1 GND nmos
M2 VO- VDD VDD VDD pmos
M3 N2 VREPLICA GND GND nmos
M4 VO+ RST VDD VDD pmos
M5 N1 VDD N2 GND nmos
M6 VO+ VI- N1 GND nmos
M7 VO+ VC VDD VDD pmos
M8 VO- VC VDD VDD pmos

M1 n0 n0 n3 VDD pmos
M2 n2 n2 n5 VDD pmos
M3 n0 n0 VDD VDD pmos
M4 n5 label_net_0 n4 VDD pmos
M5 n4 label_net_1 VDD VDD pmos
M6 n3 label_net_2 n4 VDD pmos
M7 n1 VDD n6 GND nmos
M8 label_net_3 label_net_4 n6 GND nmos
M9 n8 label_net_5 n6 GND nmos
M10 n2 n2 n7 VDD pmos
M11 n2 n2 n8 GND nmos
M12 n2 n2 label_net_3 GND nmos
M13 n7 label_net_6 n4 VDD pmos
M14 n6 label_net_7 GND GND nmos
M15 n0 n0 n1 GND nmos
M16 n2 n2 VDD VDD pmos
M17 n2 n2 GND GND nmos
M18 n0 n0 GND GND nmos

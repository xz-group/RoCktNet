IBIAS1 RB VEE 200u
IBIAS2 RBb VEE 200u
QRB O Q4_BASE RB npn
QRBb Ob Q3_BASE RBb npn
QDb Q3_BASE Q3_BASE RB npn
QD Q4_BASE Q4_BASE RBb npn
RC2 VCC Ob 800
RD2 VCC Q3_BASE 1.6k
RD1 VCC Q4_BASE 1.6k
RC1 VCC O 800

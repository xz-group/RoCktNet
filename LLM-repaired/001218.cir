I1 RB VEE 200u
I2 RBB VEE 200u
Q1 O Q4_BASE RB npn
Q2 OB Q3_BASE RBB npn
Q3 Q3_BASE Q3_BASE RB npn
Q4 Q4_BASE Q4_BASE RBB npn
R1 VCC OB 800
R2 VCC Q3_BASE 1.6k
R3 VCC Q4_BASE 1.6k
R4 VCC O 800

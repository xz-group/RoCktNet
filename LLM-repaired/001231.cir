M4 OUT1 VCASC N1 GND nmos
M1 OUT2 VCASC N2 GND nmos
M3 N1 VIN N3 GND nmos
M2 N2 VREF N3 GND nmos
I1 N3 GND

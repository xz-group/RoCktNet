M1 N0 V_replica GND GND nmos
M2 VDD N0 VDD GND nmos
M3 VDD rst N0 GND nmos
M4 Vo_minus Vi_plus VDD GND nmos
M5 VDD Vo_minus VDD GND nmos
M6 N0 V_replica GND GND nmos
M7 VDD VDD VDD GND nmos
M8 Vo_minus VDD VDD VDD pmos
M9 VDD VDD VDD VDD pmos
M10 Vo_minus VDD VDD GND nmos

M1 n0 n4 GND GND nmos
M2 VDD n0 VDD GND nmos
M3 VDD label_net_0 n0 GND nmos
M4 n2 label_net_1 VDD GND nmos
M5 VDD n2 VDD GND nmos
M6 n0 n4 GND GND nmos
M7 VDD VDD VDD GND nmos
M8 n2 VDD VDD VDD pmos
M9 VDD VDD VDD VDD pmos
M10 n2 VDD VDD GND nmos

M1 VDD VDD VDD VDD pmos
M2 VDD VDD label_net_0 VDD pmos
M3 VDD VDD label_net_1 VDD pmos
M4 VDD VDD n1 VDD pmos
M5 VDD VDD VDD VDD pmos
M6 VDD VDD n0 GND nmos
M7 VDD VDD n0 GND nmos
M8 n0 label_net_2 n0 GND nmos
M9 VDD VDD n1 VDD pmos
M10 VDD VDD VDD GND nmos

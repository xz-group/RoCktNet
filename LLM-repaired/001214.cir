M1 n8 GND GND GND nmos
M2 GND n1 GND GND nmos
M3 n0 n10 GND GND nmos
M4 n9 n2 VDD VDD pmos
M5 n10 n11 GND GND nmos
M6 n4 n4 n9 VDD pmos
M7 GND n9 n2 VDD pmos
M8 n1 label_net_0 GND GND nmos
M9 VDD GND n1 GND nmos
M10 n10 n5 VDD VDD pmos
M11 n1 n3 VDD VDD pmos
M12 n0 n6 VDD VDD pmos
M13 n8 n7 VDD VDD pmos
M14 GND GND n1 VDD pmos
M15 GND n7 VDD VDD pmos
M16 n4 n10 n11 GND nmos
M17 n11 n10 GND GND nmos
M18 n2 n4 n3 GND nmos

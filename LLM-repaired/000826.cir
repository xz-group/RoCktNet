M1 n1 n1 n0 VDD pmos
M2 n1 n1 n2 VDD pmos
M3 n2 n6 VDD VDD pmos
M4 n1 n4 n3 GND nmos
M5 n3 n5 GND GND nmos
M6 n3 n3 GND GND nmos
M7 n1 n4 n3 GND nmos
M8 n3 n3 GND GND nmos
M9 n1 n6 n3 GND nmos
M10 n3 n5 GND GND nmos
M11 n0 n7 VDD VDD pmos
M12 n1 n7 n3 GND nmos
M13 n1 label_net_0 n1 VDD pmos

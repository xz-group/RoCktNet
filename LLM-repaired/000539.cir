I1 n0 GND
M1 n2 label_net_0 n0 GND nmos
M2 n1 n3 VDD VDD pmos
M3 n2 n3 VDD VDD pmos
M4 n1 label_net_2 n0 GND nmos

D1 GND n1 diode
M1 label_net_0 label_net_1 n1 GND nmos
M2 VDD n1 n0 GND nmos
M3 label_net_2 label_net_3 n0 GND nmos

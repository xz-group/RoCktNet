M1 N_L +VIN N_TAIL VDD pmos
M2 N_R -VIN N_TAIL VDD pmos
M3 +IOUT DI_BAR N_L VDD pmos
M4 +IOUT DI N_R VDD pmos
M5 N_TAIL VBB VDD VDD pmos
M6 -IOUT DI_BAR N_R VDD pmos
M7 -IOUT DI N_L VDD pmos

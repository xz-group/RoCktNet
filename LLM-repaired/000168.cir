I1 n3 GND
M1 n2 label_net_0 GND GND nmos
M2 n2 n0 GND GND nmos
M3 n0 label_net_1 GND GND nmos
M4 n4 n2 GND GND nmos
M5 n0 label_net_2 n5 VDD pmos
M6 n4 n2 VDD VDD pmos
M7 n5 n3 VDD VDD pmos
M8 n0 n2 GND GND nmos
M9 n1 n0 GND GND nmos
M10 n2 label_net_3 n5 VDD pmos
M11 n1 n0 VDD VDD pmos
M12 n3 n3 VDD VDD pmos

I1 n0 GND
M1 n3 n2 VDD VDD pmos
I2 n3 GND
Q1 n2 label_net_0 n0 npn
M2 n1 n1 VDD VDD pmos
Q2 n1 n3 n0 npn
M3 n2 n2 VDD VDD pmos
Q3 n1 label_net_1 n0 npn

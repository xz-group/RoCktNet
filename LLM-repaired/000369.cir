I5ptat N0 GND
M6 V1m N2 VDD VDD pmos
I4ptat V1m GND
Q6 N2 Vcp N0 npn
M8 N1 N1 VDD VDD pmos
Q7 N1 V1m N0 npn
M7 N2 N2 VDD VDD pmos
Q8 N1 Vcm N0 npn

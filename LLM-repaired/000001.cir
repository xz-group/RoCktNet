M1 n5 label_net_0 GND GND nmos
M2 n4 n5 GND GND nmos
M3 n0 n1 GND GND nmos
M4 n4 label_net_1 n6 VDD pmos
M5 n6 n5 n3 VDD pmos
M6 n1 label_net_2 GND GND nmos
M7 n2 n1 n3 VDD pmos
M8 n0 label_net_3 n2 VDD pmos

I1 N2 GND
I2 N1 GND
M1 N3 VIN_PLUS N1 GND nmos
M2 N4 VREF_PLUS N1 GND nmos
M3 N3 VIN_MINUS N2 GND nmos
M4 N4 VREF_MINUS N2 GND nmos
M5 N3 N4 VDD VDD pmos
M6 N4 N4 VDD VDD pmos
M7 N5 N4 VDD VDD pmos
M8 N6 N3 VDD VDD pmos
M9 N5 N6 VDD VDD pmos
M10 N6 N5 VDD VDD pmos
M11 N7 CLKB N5 VDD pmos
M12 N8 CLKB N6 VDD pmos
M13 N7 N8 GND GND nmos
M14 N7 CLKB GND GND nmos
M15 N8 N7 GND GND nmos
M16 N8 CLKB GND GND nmos
M17 DOUT_PLUS N8 GND GND nmos
M18 DOUT_PLUS DOUT_MINUS GND GND nmos
M19 DOUT_MINUS DOUT_PLUS GND GND nmos
M20 DOUT_MINUS N7 GND GND nmos
M21 DOUT_PLUS DOUT_MINUS VDD VDD pmos
M22 DOUT_MINUS DOUT_PLUS VDD VDD pmos

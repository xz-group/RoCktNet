M1 n2 label_net_0 n4 GND nmos
M2 n3 label_net_1 n2 GND nmos
M3 n4 label_net_2 GND GND nmos
M4 n0 n1 label_net_3 VDD pmos
M5 n0 label_net_4 n2 GND nmos
M6 n3 label_net_5 n1 VDD pmos

m1cas N2 r2 N4 GND nmos
m2 outn inp N2 GND nmos
m1 N4 r1 GND GND nmos
m5 outp N1 LABEL_NET_3 VDD pmos
m3 outp inn N2 GND nmos
m4 outn r3 N1 VDD pmos

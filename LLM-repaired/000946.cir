A1 (V3F GND N_IN) amplifier
C3B N_IN V3F 2f
C2B VR_XD2 N_IN 2f
C1B VCMO N_IN 2f
C4 VCMO N_IN 2f
S1 (V3F N_OUT) switch_ideal
C3 N_OUT GND 3c

A2f (V3f GND N_IN) amplifier
C3B N_IN V3f 2f
C2B Vr_x_D2 N_IN 2f
C1B VCMO N_IN 2f
C4 VCMO N_IN 2f
S1 (V3f N_OUT) switch_ideal
C3 N_OUT GND 3c

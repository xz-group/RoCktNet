M1 n4 n0 n1 GND nmos
M2 n0 label_net_0 n6 VDD pmos
M3 n0 n4 n2 GND nmos
M4 n4 label_net_1 n6 VDD pmos
M5 n2 label_net_2 n3 GND nmos
M6 n4 n0 n6 VDD pmos
M7 n1 label_net_3 n5 GND nmos
M8 n0 n4 n6 VDD pmos
M9 n1 label_net_4 n3 GND nmos
M10 n5 label_net_5 GND GND nmos
M11 n3 label_net_6 GND GND nmos
M12 n2 label_net_7 n5 GND nmos

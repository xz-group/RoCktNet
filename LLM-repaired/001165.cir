I1 label_net_0 n1
I2 n0 GND
Q1 n2 n0 GND npn
Q2 n1 label_net_1 n2 npn
M1 n0 label_net_2 n0 VDD pmos
M2 label_net_3 n1 n0 GND nmos

I1 VDD n1
M1 VDD label_net_0 n0 GND nmos
I2 n0 label_net_1
M2 n2 label_net_2 n0 GND nmos
M3 GND label_net_3 n1 VDD pmos
M4 n2 label_net_4 n1 VDD pmos

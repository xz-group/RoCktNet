M1 N1 INN N4 GND nmos
M2 OUTP CLK GND GND nmos
M3 N4 BIAS GND GND nmos
M4 OUTP OUTP GND GND nmos
M5 OUTP CLK GND GND nmos
M6 N6 N6 N5 VDD pmos
M7 OUTP N6 N2 VDD pmos
M8 N1 N1 N5 VDD pmos
M9 OUTP N1 N2 VDD pmos
M10 N6 INP N4 GND nmos
M11 OUTP OUTN GND GND nmos

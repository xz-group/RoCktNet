M1 n1 label_net_0 n4 GND nmos
M2 n0 n3 GND GND nmos
M3 n4 label_net_1 GND GND nmos
M4 n0 n0 GND GND nmos
M5 n0 n3 GND GND nmos
M6 n6 n6 n5 VDD pmos
M7 n0 n6 n2 VDD pmos
M8 n1 n1 n5 VDD pmos
M9 n0 n1 n2 VDD pmos
M10 n6 label_net_2 n4 GND nmos
M11 n0 label_net_3 GND GND nmos

I1 VDD GND
I2 N3 GND
I3 N8 GND
R1 VDD N4
M1 N10 Baseband_N N8 GND nmos
R2 VDD N4
M2 N1 Baseband_N VDD GND nmos
M3 N7 Baseband_P VDD GND nmos
M4 N4 Baseband_P N3 GND nmos
M5 N9 Baseband_N N3 GND nmos
M6 N2 Baseband_P N8 GND nmos
M7 N4 N4 N9 GND nmos
M8 N4 N4 N2 GND nmos
M9 N4 N4 N5 GND nmos
M10 N4 N4 N10 GND nmos
M11 N4 f2_t N4 GND nmos
M12 N4 N4 N7 GND nmos
M13 N4 f3_t N7 GND nmos
M14 N4 N4 N5 GND nmos
M15 N4 N4 N9 GND nmos
M16 N4 f2_t N2 GND nmos
M17 N4 N4 N1 GND nmos
M18 N4 f3_t N4 GND nmos

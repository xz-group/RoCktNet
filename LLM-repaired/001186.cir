I1 VDD GND
I2 n3 GND
I3 n8 GND
R1 VDD n4
M1 n10 n0 n8 GND nmos
R2 VDD n4
M2 n1 n0 VDD GND nmos
M3 n7 n6 VDD GND nmos
M4 n4 n6 n3 GND nmos
M5 n9 n0 n3 GND nmos
M6 n2 n6 n8 GND nmos
M7 n4 n4 n9 GND nmos
M8 n4 n4 n2 GND nmos
M9 n4 n4 n5 GND nmos
M10 n4 n4 n10 GND nmos
M11 n4 n12 n4 GND nmos
M12 n4 n4 n7 GND nmos
M13 n4 n11 n7 GND nmos
M14 n4 n4 n5 GND nmos
M15 n4 n4 n9 GND nmos
M16 n4 n12 n2 GND nmos
M17 n4 n4 n1 GND nmos
M18 n4 n11 n4 GND nmos

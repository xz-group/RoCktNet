L1 IN N1 Ls
R3 N1 OUT Rs
C5 IN OUT Cs
C4 IN N2 Cox
R1 N2 GND Rsi
C1 N2 GND Csi
C3 OUT N3 Cox
R2 N3 GND Rsi
C2 N3 GND Csi

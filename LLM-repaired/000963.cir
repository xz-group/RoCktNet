M1 GND n1 GND GND nmos
M2 GND n2 GND GND nmos
M3 n3 label_net_0 n0 VDD pmos
M4 GND n0 GND GND nmos
M5 n3 n3 VDD VDD pmos
M6 VDD n2 VDD VDD pmos
M7 n3 n0 n0 VDD pmos
M8 n2 n1 n3 VDD pmos

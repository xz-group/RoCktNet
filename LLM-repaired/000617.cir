M1 n1 n1 n0 GND nmos
M2 n0 n0 GND GND nmos
M3 n2 n0 GND GND nmos
M4 label_net_0 n1 n2 GND nmos

M2 N4 Vin2 N2 VDD pmos
M1 N0 Vin1 N2 VDD pmos
M3 Vout1 VB2 N10 VDD pmos
M4 N4 CMFB GND GND nmos
M5 N0 CMFB GND GND nmos
M6 N7 VB1 VDD VDD pmos
M7 Vout2 VB2 N7 VDD pmos
M8 Vout2 VB3 N4 GND nmos
M9 Vout1 VB3 N0 GND nmos
M10 N10 VB1 VDD VDD pmos
M11 N2 VB1 VDD VDD pmos

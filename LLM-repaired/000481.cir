M1 Vout_plus Vout_minus VDD VDD pmos
I1 N0 GND
M2 Vout_minus Vout_plus VDD VDD pmos
M3 Vout_plus Vin_plus N0 GND nmos
M4 Vout_minus Vin_minus N0 GND nmos
M5 Vout_minus Vclk2 Vout_plus VDD pmos
M0 Vout_minus Vbiasn Vout_plus VDD pmos

M1 BP BP VDD VDD pmos
M2 N2 N1 BP VDD pmos
M3 N2 BN GND GND nmos
M4 N2 N2 GND GND nmos
M5 BN BN GND GND nmos
M6 BN N1 N4 VDD pmos
M7 N4 BP VDD VDD pmos
M8 N3 BP VDD VDD pmos
M9 N1 N1 N3 VDD pmos
M10 V2I V2I GND GND nmos
M11 N1 V2I GND GND nmos
M12 BN N2 GND GND nmos

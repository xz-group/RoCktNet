M1 n0 n6 VDD VDD pmos
M2 n2 n4 n5 GND nmos
M3 n3 label_net_0 GND GND nmos
M4 n6 n0 VDD VDD pmos
M5 GND label_net_1 GND GND nmos
M6 n1 n4 n2 VDD pmos
M7 n6 label_net_2 VDD VDD pmos
M8 n3 label_net_3 GND GND nmos
M9 n6 n0 n1 GND nmos
M10 n1 n4 n3 GND nmos
M11 n0 n6 n2 GND nmos
M12 n5 label_net_4 GND GND nmos
M13 n0 VDD VDD VDD pmos

M1 n0 GND VDD VDD pmos
M2 n4 n1 GND GND nmos
M3 n0 n0 VDD VDD pmos
M4 n1 n2 GND GND nmos
M5 n0 n0 GND GND nmos
M6 n0 n0 VDD VDD pmos
M7 n2 n3 GND GND nmos
M8 n0 label_net_1 n0 VDD pmos
M9 n6 n0 GND GND nmos
M10 n3 n5 n6 GND nmos
M11 n0 n0 VDD VDD pmos
M12 n2 n3 VDD VDD pmos
M13 n1 n2 VDD VDD pmos
M14 n4 n1 VDD VDD pmos
M15 n3 n5 VDD VDD pmos
M16 n0 label_net_3 VDD VDD pmos

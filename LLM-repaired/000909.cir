M6 Vg GND VDD VDD pmos
M15 Out N1 GND GND nmos
M5 Vg Vg VDD VDD pmos
M13 N1 N2 GND GND nmos
M7 Vg Vg GND GND nmos
M3 Vg Vg VDD VDD pmos
M11 N2 N3 GND GND nmos
M2 Vg b Vg VDD pmos
M8 N6 Vg GND GND nmos
M9 N3 In N6 GND nmos
M4 Vg Vg VDD VDD pmos
M12 N2 N3 VDD VDD pmos
M14 N1 N2 VDD VDD pmos
M16 Out N1 VDD VDD pmos
M10 N3 In VDD VDD pmos
M1 Vg a VDD VDD pmos

I1 N1 GND
I2 N8 GND
M1 BBI- LOI+ N9 GND nmos
M2 BBI+ LOI+ N7 GND nmos
M3 N10 VCASCODE N8 GND nmos
R1 N8 RF- R/2
R2 N1 RF+ R/2
M4 N7 S1 N4 GND nmos
M5 N4 VCASCODE N1 GND nmos
M6 N9 S1 N10 GND nmos
M7 BBI- LOI- N7 GND nmos
M8 BBI+ LOI- N9 GND nmos
M9 N8 S2 N1 GND nmos

M1 n3 n1 n0 VDD pmos
M2 n7 n3 n0 VDD pmos
M3 n2 n7 n0 VDD pmos
M4 n1 n2 n0 VDD pmos
M5 n4 n5 n2 VDD pmos
M6 n11 n5 n3 VDD pmos
M7 n8 n5 n7 VDD pmos
M8 n6 n5 n1 VDD pmos
M9 n4 label_net_1 GND GND nmos
D1 GND n6 diode
D2 GND n8 diode
M10 n11 label_net_2 GND GND nmos
D3 GND n4 diode
D4 GND n11 diode
M11 n6 label_net_3 GND GND nmos
M12 n8 label_net_4 GND GND nmos

M4 Out_plus Out_minus VSS GND nmos
M5 N1 Vbias VDD VDD pmos
M3 Out_minus Out_plus VSS GND nmos
S1 (Out_minus Out_plus) switch_ideal
M2 N1 In_minus Out_plus GND nmos
M1 N1 In_plus Out_minus GND nmos

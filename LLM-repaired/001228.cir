I1 N1 GND
I2 VDD Vop
I3 VDD Von
M1 N2 Vip N1 GND nmos
M2 N3 Vin N1 GND nmos
M3 VDD Vcm N2 GND nmos
M4 VDD Vcm N3 GND nmos
M5 N4 N3 GND GND nmos
M6 N5 N2 GND GND nmos
M7 Vop Vb N4 GND nmos
M8 Von Vb N5 GND nmos

I1 N1 GND
I2 VDD VOP
I3 VDD VON
M1 N2 VIP N1 GND nmos
M2 N3 VIN N1 GND nmos
M3 VDD VCM N2 GND nmos
M4 VDD VCM N3 GND nmos
M5 N4 N3 GND GND nmos
M6 N5 N2 GND GND nmos
M7 VOP VB N4 GND nmos
M8 VON VB N5 GND nmos

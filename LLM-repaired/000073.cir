M1 n1 label_net_0 n0 GND nmos
M2 n3 label_net_1 n0 GND nmos
M3 n0 n7 GND GND nmos
M4 n6 n7 VDD VDD pmos
M5 n2 label_net_2 n0 GND nmos
M6 n4 label_net_3 n3 GND nmos
M7 n2 label_net_4 n6 VDD pmos
M8 n4 label_net_5 n0 GND nmos
M9 n3 label_net_6 n0 GND nmos
M10 n4 label_net_7 n5 VDD pmos
M11 n5 label_net_8 VDD VDD pmos
M12 n2 label_net_9 n1 GND nmos
M13 n0 label_net_10 n6 VDD pmos

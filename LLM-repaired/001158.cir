M1 N8 N2 N12 VDD pmos
M2 N5 LABEL_NET_0 N10 GND nmos
M3 N10 LABEL_NET_1 N15 GND nmos
M4 N1 N16 N19 GND nmos
M5 N6 N15 N17 GND nmos
M6 N17 N9 GND GND nmos
M7 N2 N18 N20 GND nmos
M8 N20 N7 GND GND nmos
M9 N2 N0 N8 VDD pmos
M10 N5 N2 N11 VDD pmos
M11 N19 N9 GND GND nmos
M12 N6 N14 N5 VDD pmos
M13 N5 LABEL_NET_3 N10 GND nmos
M14 N9 LABEL_NET_4 GND GND nmos
M15 N5 N2 N11 VDD pmos
M16 N11 N6 N11 VDD pmos
M17 N11 N1 LABEL_NET_5 VDD pmos
M18 N1 N14 N5 VDD pmos
M19 N12 N3 LABEL_NET_6 VDD pmos

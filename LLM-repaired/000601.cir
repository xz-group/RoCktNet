M1 n1 n0 VDD VDD pmos
M2 n0 label_net_0 VDD VDD pmos
M3 GND label_net_1 GND GND nmos
M4 n0 n1 VDD VDD pmos
M5 n1 label_net_2 VDD VDD pmos
M6 n0 n1 n2 GND nmos
M7 n1 n0 n3 GND nmos
M8 n3 label_net_3 GND GND nmos
M9 GND GND GND GND nmos
M10 n2 VDD GND GND nmos
M11 GND label_net_4 GND GND nmos

I1 n11 GND
M1 n1 n11 VDD VDD pmos
M2 n1 n1 GND GND nmos
M3 n9 n5 GND GND nmos
M4 n1 n1 n0 VDD pmos
M5 n2 n2 VDD VDD pmos
M6 n7 n2 VDD VDD pmos
M7 n11 n11 n10 VDD pmos
M8 n8 n1 GND GND nmos
M9 n2 n1 GND GND nmos
M10 n0 n11 VDD VDD pmos
M11 n1 label_net_1 n3 VDD pmos
M12 n5 n6 n7 VDD pmos
M13 n3 n11 VDD VDD pmos
M14 n9 n5 VDD VDD pmos
M15 n5 n6 n8 GND nmos
M16 n4 n11 VDD VDD pmos
M17 n10 n11 VDD VDD pmos
M18 n1 label_net_3 n10 VDD pmos
M19 n1 label_net_4 n4 VDD pmos

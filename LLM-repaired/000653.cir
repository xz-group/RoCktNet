M1 N1 VIP N3 GNDA nmos
M2 N2 VIN N3 GNDA nmos
M3 N3 VCMFB GNDA GNDA nmos
M4 N3 VB5 GNDA GNDA nmos
M5 N1 VB1 VDDA VDDA pmos
M6 N2 VB1 VDDA VDDA pmos
M7 N4 VB2 N1 VDDA pmos
M8 N5 VB2 N2 VDDA pmos
M9 VON VB3 N4 VDDA pmos
M10 VOP VB3 N5 VDDA pmos
M11 VON VB4 N6 GNDA nmos
M12 VOP VB4 N7 GNDA nmos
M13 N6 VB5 GNDA GNDA nmos
M14 N7 VB5 GNDA GNDA nmos

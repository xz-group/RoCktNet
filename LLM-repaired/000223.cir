M1 n1 n3 GND GND nmos
M2 n0 n1 VDD VDD pmos
M3 n0 n1 GND GND nmos
M4 n2 label_net_0 n2 GND nmos
M5 GND n3 n2 GND nmos
M6 n1 n3 VDD VDD pmos
M7 n0 VDD VDD GND nmos
M8 n1 label_net_2 VDD VDD pmos

M1 n6 n4 label_net_0 VDD pmos
M2 n3 n1 label_net_1 VDD pmos
M3 n5 n2 VDD VDD pmos
M4 n5 n6 GND GND nmos
M5 n4 n5 GND GND nmos
M6 n6 n6 GND GND nmos
M7 n3 n3 n0 GND nmos
R1 n0 GND
M8 n2 n2 n1 VDD pmos
M9 n4 n4 n7 VDD pmos
M10 label_net_2 n7 VDD VDD pmos
M11 n0 n3 GND GND nmos
M12 n2 n5 n0 GND nmos
S1 n3 GND switch_ideal

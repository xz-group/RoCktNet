M1 n4 n8 n1 VDD pmos
M2 n6 n10 GND GND nmos
M3 n4 n9 n0 GND nmos
M4 n3 n9 n6 GND nmos
M5 n3 n8 n2 VDD pmos
M6 n1 n4 VDD VDD pmos
M7 n0 n10 GND GND nmos
I1 VDD n5
M8 n2 n4 VDD VDD pmos
M9 n0 n11 n5 VDD pmos
M10 n6 n7 n5 VDD pmos
I2 n6 GND
M11 n2 label_net_0 n6 GND nmos
M12 n1 label_net_1 n6 GND nmos

M1 n0 n0 VDD VDD pmos
M2 n5 n5 VDD VDD pmos
M3 n0 n8 n1 GND nmos
M4 n10 n8 n4 GND nmos
M5 n5 n2 n1 GND nmos
M6 n4 n7 GND GND nmos
M7 n10 n0 VDD VDD pmos
M8 n1 n7 GND GND nmos
M9 n6 n6 VDD VDD pmos
M10 n0 n0 VDD VDD pmos
M11 n0 n8 n1 GND nmos
M12 n6 n10 n1 GND nmos
M13 n2 n0 VDD VDD pmos
M14 n3 n7 GND GND nmos
M15 n2 n8 n3 GND nmos

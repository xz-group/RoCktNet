M1 n9 n2 VDD VDD pmos
M2 n10 n8 n4 GND nmos
M3 n0 label_net_0 n3 VDD pmos
M4 n13 n18 VDD VDD pmos
M5 n15 n18 n4 GND nmos
M6 n1 n12 n4 GND nmos
M7 n16 n8 VDD VDD pmos
M8 n0 n17 n9 VDD pmos
M9 n0 n17 n4 GND nmos
M10 n12 n0 VDD VDD pmos
M11 n17 label_net_1 n11 GND nmos
M12 n11 n7 n10 GND nmos
M13 n17 label_net_2 n16 VDD pmos
M14 n18 n6 n5 VDD pmos
M15 n0 n2 n4 GND nmos
M16 n3 label_net_3 VDD VDD pmos
M17 n0 label_net_4 n1 GND nmos
M18 n5 n18 VDD VDD pmos
M19 n18 n14 n15 GND nmos
M20 n18 label_net_5 VDD VDD pmos
M21 n16 n7 VDD VDD pmos
M22 n13 n18 n4 GND nmos
M23 n12 n0 n4 GND nmos
M24 n18 n6 n18 GND nmos
M25 n18 n14 n12 VDD pmos

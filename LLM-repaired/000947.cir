M1 n3 n8 n2 GND nmos
M2 n6 n8 GND GND nmos
M3 n3 label_net_0 n1 VDD pmos
M4 n10 n9 n7 GND nmos
M5 n2 label_net_1 GND GND nmos
M6 n4 label_net_2 n1 VDD pmos
M7 n4 n0 n2 GND nmos
M8 n10 n11 n1 VDD pmos
M9 n7 n0 GND GND nmos
M10 n4 n5 n1 VDD pmos
M11 n5 n9 n6 GND nmos
M12 n3 label_net_3 n1 VDD pmos
M13 n5 n11 n1 VDD pmos
M14 n1 label_net_5 VDD VDD pmos

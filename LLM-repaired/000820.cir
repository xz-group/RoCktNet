I1 VDD n0
M1 n4 n4 VDD VDD pmos
M2 n2 n1 GND GND nmos
M3 n1 n4 VDD VDD pmos
M4 n2 n1 VDD VDD pmos
M5 n4 label_net_0 n3 GND nmos
M6 n0 n0 GND GND nmos
M7 n3 n0 GND GND nmos
M8 n1 label_net_1 n3 GND nmos

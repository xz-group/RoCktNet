R1 N1 substrate 0.03
R2 VSS substrate 0.14
C1 VDD N1 1.26n
C2 VDD VSS 2.28n

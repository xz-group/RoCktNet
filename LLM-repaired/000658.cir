M5 N1 LABEL_NET_0 VDD VDD pmos
M4 outn LABEL_NET_1 VDD VDD pmos
M7 N0 N0 GND GND nmos
M2 N2 N2 GND GND nmos
M1 N2 inn N1 VDD pmos
M6 outp N0 GND GND nmos
M3 outn N2 GND GND nmos
M8 outp LABEL_NET_3 VDD VDD pmos
M9 N0 inp N1 VDD pmos

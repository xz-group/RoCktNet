Z (N0 N4) resistor
MS3 N0 N4 VSS GND nmos
MS1 N4 N4 VSS GND nmos
MS2 N4 VB VD VDD pmos
MS4 N0 VB VD VDD pmos

R1 n0 n4
M1 n0 n4 n1 GND nmos
M2 n4 n4 n1 GND nmos
M3 n4 n2 n3 VDD pmos
M4 n0 n2 n3 VDD pmos

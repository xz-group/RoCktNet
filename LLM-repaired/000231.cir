M1 VDD Vip N3 GND nmos
M2 VDD Vin N4 GND nmos
M3 N5 N3 N7 GND nmos
M4 N6 N4 N7 GND nmos
M5 Von VB3 N5 GND nmos
M6 Vop VB3 N6 GND nmos
M7 Von VB2 N1 VDD pmos
M8 Vop VB2 N2 VDD pmos
M9 N1 VB1 VDD VDD pmos
M10 N2 VB1 VDD VDD pmos
M11 N3 VB5 GND GND nmos
M12 N7 VB5 GND GND nmos
M13 N7 VCMFB GND GND nmos
M14 N4 VB5 GND GND nmos

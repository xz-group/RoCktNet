M1 n1 label_net_0 n3 GND nmos
M2 n5 label_net_1 GND GND nmos
M3 n6 label_net_2 n4 GND nmos
M4 n6 label_net_3 n0 VDD pmos
M5 n0 n7 n2 VDD pmos
M6 n1 n7 n2 VDD pmos
M7 n8 label_net_4 n1 VDD pmos
M8 n3 label_net_5 GND GND nmos
M9 n4 label_net_6 GND GND nmos
M10 n0 label_net_7 n3 GND nmos
M11 n8 label_net_8 n5 GND nmos

I1 VDD VOUT
M2 VOUT IN1 GND GND nmos
M3 VOUT IN2 GND GND nmos
M4 VOUT IN3 GND GND nmos
M1 VOUT IN4 GND GND nmos
M5 VDD VDD VOUT GND nmos

M1 IIN N1 GND GND nmos
M2 VDD N2 N1 GND nmos
M3 VDD N2 N3 GND nmos
M4 IOUT N3 GND GND nmos
IDIR N1 GND
IINV N3 GND

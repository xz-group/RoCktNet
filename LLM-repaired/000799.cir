M1 Iin N1 GND GND nmos
M2 VDD N2 N1 GND nmos
M3 VDD N2 N3 GND nmos
M4 Iout N3 GND GND nmos
IDIR N1 GND
IINV N3 GND

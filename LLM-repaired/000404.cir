M1 n1 label_net_0 GND GND nmos
M2 n0 n2 VDD VDD pmos
M3 n0 label_net_1 VDD VDD pmos
M4 n2 label_net_2 VDD VDD pmos
M5 n2 label_net_3 n1 GND nmos
M6 n2 label_net_4 VDD VDD pmos
M7 n0 label_net_5 n1 GND nmos

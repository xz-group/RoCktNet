M1 VCO_Supply_V N4 full_Vdd VDD pmos
M2 N7 N7 full_Vdd VDD pmos
M3 N7 VCO_Supply_V N1 GND nmos
M4 N4 N5 N1 GND nmos
M5 N6 N5 GND GND nmos
M6 N3 N3 GND GND nmos
M7 N4 N7 full_Vdd VDD pmos
M8 N3 N6 full_Vdd VDD pmos
M9 N1 N3 GND GND nmos
M10 N6 N6 full_Vdd VDD pmos
C1 VCO_Supply_V GND
M11 GND GND N5 VDD pmos
M12 GND N5 GND GND nmos

I1 VDD N1
I2 N2 GND
MC17 VDD N1 N2 N2 nmos
MC16 N1 N1 N0 N0 nmos
MC15 N0 N0 VLOW VLOW nmos
MC12 N2 N2 M12GATE M12GATE nmos
MC13 N2 N2 M13GATE M13GATE nmos

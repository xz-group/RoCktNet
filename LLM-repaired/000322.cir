M1 outp bias2 N10 VDD pmos
M2 N10 bias1 VDD VDD pmos
M3 N4 inm N5 GND nmos
M4 outp bias4 N4 GND nmos
M5 N5 bias3 N8 GND nmos
M6 outm bias4 N6 GND nmos
M7 N7 bias1 VDD VDD pmos
M8 outm bias2 N7 VDD pmos
M9 N3 cmfb GND GND nmos
M10 N8 cmref GND GND nmos
M11 N6 inp N5 GND nmos
M12 N5 bias3 N3 GND nmos

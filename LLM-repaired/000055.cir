M1 n0 n0 VDD VDD pmos
M2 n3 n3 GND GND nmos
M3 n1 label_net_0 n2 VDD pmos
M4 n4 n0 VDD VDD pmos
M5 n3 label_net_1 n2 VDD pmos
M6 n3 n1 GND GND nmos
M7 n1 n1 GND GND nmos
M8 n1 n3 GND GND nmos
M9 n0 n3 GND GND nmos
M10 n4 n1 GND GND nmos

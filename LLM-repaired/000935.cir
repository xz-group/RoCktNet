M1 n2 label_net_1 n1 GND nmos
M2 n2 label_net_2 n0 GND nmos
M3 n2 n3 n1 GND nmos
M4 n0 label_net_4 GND GND nmos
M5 n2 n3 n0 GND nmos
M6 n1 label_net_5 GND GND nmos

M1 n2 label_net_0 n1 GND nmos
M2 n0 n2 VDD VDD pmos
M3 n0 label_net_1 n1 GND nmos
M4 n2 n0 VDD VDD pmos
M5 n1 label_net_3 GND GND nmos

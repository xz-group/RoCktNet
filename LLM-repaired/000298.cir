M2 Q_BAR D N1 GND nmos
M5 Q Q_BAR VDD VDD pmos
M3 Q D_BAR N1 GND nmos
M4 Q_BAR Q VDD VDD pmos
M1 N1 CK GND GND nmos

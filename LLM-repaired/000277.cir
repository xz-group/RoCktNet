M1 N0 Vi1 N2 VDD pmos
M2 VO N0 GND GND nmos
M3 N0 N0 GND GND nmos
M4 VO Vi2 N2 VDD pmos
M5 N2 VB N3 VDD pmos
M6 VDD VG1 N3 GND nmos
M7 VDD VG2 N3 GND nmos

M1 n3 n5 n1 GND nmos
M2 n1 label_net_1 GND GND nmos
M3 n2 label_net_2 GND GND nmos
M4 n3 n4 label_net_4 VDD pmos
M5 n0 n4 label_net_5 VDD pmos
M6 n0 n5 n2 GND nmos

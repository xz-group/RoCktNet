M1 n5 n1 VDD VDD pmos
M2 n6 n3 GND GND nmos
M3 n2 n0 VDD VDD pmos
M4 n4 n3 GND GND nmos
M5 n4 label_net_0 GND GND nmos
M6 n5 n1 n6 GND nmos
M7 n6 label_net_1 GND GND nmos
M8 n5 n2 GND GND nmos
M9 n2 n0 n4 GND nmos
M10 n2 n5 GND GND nmos
M11 n6 label_net_2 n4 GND nmos

M1 n0 n0 n0 GND nmos
M2 n7 n7 n4 GND nmos
M3 n1 n1 GND GND nmos
M4 n1 n0 n6 VDD pmos
M5 n7 n7 n0 GND nmos
M6 n7 n7 n2 VDD pmos
M7 n0 n0 VDD VDD pmos
M8 n0 n0 VDD VDD pmos
M9 n2 n2 VDD VDD pmos
D1 n0 GND diode
M10 n6 n0 VDD VDD pmos
M11 n0 n0 VDD VDD pmos
M12 GND n0 n3 VDD pmos
M13 GND n5 n1 GND nmos
M14 GND n8 n6 VDD pmos
M15 n0 n0 n8 GND nmos
M16 n4 n4 GND GND nmos
M17 n3 n0 VDD VDD pmos
M18 n5 n5 n3 VDD pmos
D2 n8 GND diode

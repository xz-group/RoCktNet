I1 VDD NET_TOP_R IB
I2 NET_BOT GND 2IB
I3 VDD NET_TOP_L IB
X1 (VIN1_P VIN1_N IOUT+ IOUT- NET_TOP_L NET_BOT) amplifier
X2 (VIN1_N VIN1_P IOUT+ IOUT- NET_TOP_R NET_BOT) amplifier
X3 (IN3_P IN3_N NET_TOP_L NET_TOP_R) amplifier

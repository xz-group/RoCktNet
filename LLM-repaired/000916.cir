M1 N4 in1 Vdd VDD pmos
M2 N4 in1 Vdd VDD pmos
M6 N1 in1 Vss GND nmos
M8 out N4 Vss GND nmos
M7 out N4 Vdd VDD pmos
M4 N0 in1 Vss GND nmos
M5 N4 in2 N1 GND nmos
M3 N4 in1 N0 GND nmos

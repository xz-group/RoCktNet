I1 n2 GND
D1 n4 n0 diode
I2 n1 GND
I3 n5 GND
M1 VDD n0 n1 GND nmos
M2 n0 label_net_0 GND GND nmos
M3 n3 label_net_1 n5 GND nmos
M4 n4 n3 VDD VDD pmos
M5 n4 n1 n5 GND nmos
M6 VDD n0 n2 GND nmos
M7 n3 n3 VDD VDD pmos
C1 n0 GND

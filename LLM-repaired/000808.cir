M1 n3 n1 GND VDD pmos
M2 n0 label_net_0 n3 VDD pmos
M3 n4 n2 GND VDD pmos
M4 GND n0 GND GND nmos
M5 n0 n1 GND GND nmos
M6 GND label_net_1 n4 VDD pmos
M7 GND n2 GND GND nmos
M8 n0 GND GND VDD pmos
M9 GND n0 GND VDD pmos
M10 n0 GND n0 GND nmos

I1 n0 GND
M1 n2 n1 GND GND nmos
M2 n3 n3 n2 GND nmos
M3 n4 n1 GND GND nmos
M4 n1 n3 n4 GND nmos
M5 n1 n0 label_net_0 VDD pmos
M6 n0 n0 label_net_1 VDD pmos
M7 n3 n0 label_net_2 VDD pmos

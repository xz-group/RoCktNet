M1 N3 N3 VSS GND nmos
M2 N7 N7 N6 VDD pmos
M3 OUT N7 N1 GND nmos
M4 N7 N0 VSS GND nmos
M5 OUT N7 N4 VDD pmos
M6 N0 N0 VSS GND nmos
M7 N7 N7 N3 GND nmos
M8 N6 N6 VDD VDD pmos
M9 N7 IN_PLUS N8 VDD pmos
M10 N0 IN_MINUS N8 VDD pmos
M11 N8 IBIAS VDD VDD pmos
M12 N1 N3 VSS GND nmos
M13 N4 N6 VDD VDD pmos
M14 IBIAS IBIAS VDD VDD pmos

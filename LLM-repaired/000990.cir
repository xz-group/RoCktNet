M1 GND GND GND GND nmos
M2 GND GND VDD VDD pmos
M3 GND n0 GND VDD pmos
M4 GND label_net_0 GND GND nmos
M5 GND n0 GND GND nmos
M6 GND label_net_1 n1 GND nmos
M7 GND label_net_2 GND GND nmos
M8 GND label_net_3 n1 GND nmos
M9 n0 GND GND GND nmos
M10 GND label_net_4 GND GND nmos
M11 GND n0 GND VDD pmos
M12 GND label_net_5 n1 GND nmos
M13 GND GND VDD VDD pmos
M14 GND label_net_6 GND GND nmos
M15 GND GND n0 VDD pmos

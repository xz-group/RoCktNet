M1 GND GND GND GND nmos
M2 GND GND VDD VDD pmos
M3 GND CK2 GND VDD pmos
M4 GND LABEL_NET_0 GND GND nmos
M5 GND CK2 GND GND nmos
M6 GND LABEL_NET_1 N1 GND nmos
M7 GND LABEL_NET_2 GND GND nmos
M8 GND OFFSET N1 GND nmos
M9 CK2 GND GND GND nmos
M10 GND Data GND GND nmos
M11 GND CK2 GND VDD pmos
M12 GND CK1 N1 GND nmos
M13 GND GND VDD VDD pmos
M14 GND H3_14 GND GND nmos
M15 GND GND CK2 VDD pmos

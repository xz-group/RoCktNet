M1 n5 n0 n2 GND nmos
M2 n2 n4 GND GND nmos
M3 n3 n4 GND GND nmos
M4 n3 n3 VDD VDD pmos
M5 n5 n0 n1 VDD pmos
M6 n6 n5 VDD VDD pmos
M7 n6 n5 GND GND nmos
M8 n1 n3 VDD VDD pmos

M1 N5 In N2 GND nmos
M2 N2 Vc GND GND nmos
M3 N3 Vc GND GND nmos
M4 N3 N3 VDD VDD pmos
M5 N5 In N1 VDD pmos
M6 Out N5 VDD VDD pmos
M7 Out N5 GND GND nmos
M8 N1 N3 VDD VDD pmos

M1 OUT+ IN- NTAIL GND nmos
M2 OUT- IN+ NTAIL GND nmos
M3 N1 VN2 GND GND nmos
M4 NTAIL VN1 N1 GND nmos
M5 OUT- VBP VDD VDD pmos
M6 OUT- OUT- VDD VDD pmos
M7 OUT+ VBP VDD VDD pmos
M8 OUT+ OUT+ VDD VDD pmos

M1 OUT+ IN- NTAIL GND nmos
M2 OUT- IN+ NTAIL GND nmos
M3 N1 Vn2 GND GND nmos
M4 NTAIL Vn1 N1 GND nmos
M5 OUT- Vbp VDD VDD pmos
M6 OUT- OUT- VDD VDD pmos
M7 OUT+ Vbp VDD VDD pmos
M8 OUT+ OUT+ VDD VDD pmos

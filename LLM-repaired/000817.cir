I1 N5 GND
I2 N3 GND
M5 N1 N1 VDD VDD pmos
M1 N0 VIN N5 GND nmos
M3 N1 VIN N3 GND nmos
M4 N0 N4 N3 GND nmos
M2 N1 N4 N5 GND nmos
M6 N1 N0 VDD VDD pmos
M7 DELTA_I N1 VDD VDD pmos
M8 N0 N0 VDD VDD pmos

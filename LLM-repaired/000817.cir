I1 n5 GND
I2 n3 GND
M1 n1 n1 VDD VDD pmos
M2 n0 n2 n5 GND nmos
M3 n1 n2 n3 GND nmos
M4 n0 n4 n3 GND nmos
M5 n1 n4 n5 GND nmos
M6 n1 n0 VDD VDD pmos
M7 label_net_2 n1 VDD VDD pmos
M8 n0 n0 VDD VDD pmos

M1 n2 label_net_0 n3 n0 nmos
M2 n2 n1 n1 GND nmos
M3 n2 n2 VDD VDD pmos
I1 n1 GND
M4 n2 label_net_2 n1 GND nmos
I2 n0 GND
M5 n2 n2 VDD VDD pmos
M6 n2 n3 n0 GND nmos

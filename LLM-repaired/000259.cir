M1 N2 From_PD1 Vout N0 nmos
M2 N2 N1 N1 GND nmos
M3 N2 N2 VDD VDD pmos
I1 N1 GND
M4 N2 From_FD N1 GND nmos
I2 N0 GND
M5 N2 N2 VDD VDD pmos
M6 N2 Vout N0 GND nmos

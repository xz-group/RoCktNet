I1 VDD GND
M1 n2 label_net_0 n0 GND nmos
M2 n6 n6 VDD VDD pmos
M3 n0 GND GND GND nmos
M4 n5 n5 VDD VDD pmos
M5 n1 n1 GND GND nmos
M6 n3 n1 GND GND nmos
M7 n5 n8 n7 GND nmos
M8 n6 label_net_1 n7 GND nmos
M9 n7 GND GND n8 nmos
M10 n4 n4 VDD VDD pmos
M11 n1 n4 VDD VDD pmos
M12 GND GND GND GND nmos
M13 n2 n2 VDD VDD pmos
M14 n4 n0 n4 GND nmos
M15 n3 n6 VDD VDD pmos

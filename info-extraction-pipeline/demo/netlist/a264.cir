I1 VDD n2
M1 label_net_0 n0 n4 GND nmos
M2 n4 n2 GND GND nmos
M3 n2 n0 n1 GND nmos
M4 n1 n2 GND GND nmos

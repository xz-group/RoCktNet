M1 n2 n6 n4 VDD pmos
M2 n11 label_net_0 n10 GND nmos
M3 n10 n9 GND GND nmos
M4 n2 n8 n1 GND nmos
M5 n4 n0 VDD VDD pmos
M6 n5 n6 n3 VDD pmos
M7 n5 n8 n11 GND nmos
M8 n1 label_net_3 n10 GND nmos
M9 n3 n0 VDD VDD pmos
M10 n0 n0 VDD VDD pmos
M11 n9 n9 GND GND nmos

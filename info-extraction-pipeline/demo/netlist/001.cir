R1 VDD n2
M1 n3 GND n4 GND nmos
M2 n2 n2 n1 GND nmos
M3 n5 label_net_0 n4 GND nmos
M4 n4 n2 n1 GND nmos
M5 n0 n2 n1 GND nmos
M6 VDD n0 n6 GND nmos
M7 n6 n2 n1 GND nmos
M8 n0 n3 VDD VDD pmos
M9 n5 n5 VDD VDD pmos
M10 n3 n5 VDD VDD pmos

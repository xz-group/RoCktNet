M1 n10 n12 n8 VDD pmos
M2 n1 n2 GND GND nmos
M3 n2 n9 n5 VDD pmos
M4 n0 n2 GND GND nmos
M5 n10 n15 n4 GND nmos
M6 n2 n6 label_net_0 VDD pmos
M7 n2 n18 n14 GND nmos
M8 n2 n16 n2 GND nmos
M9 n2 n16 n3 GND nmos
M10 n7 n13 n2 GND nmos
M11 n12 n15 n7 GND nmos
M12 n3 n11 GND GND nmos
M13 n12 n12 n17 VDD pmos
M14 n4 n13 n0 GND nmos
M15 n2 n2 GND GND nmos
M16 n5 label_net_1 n17 VDD pmos
M17 n14 n2 GND GND nmos
M18 n2 n9 n5 VDD pmos
M19 n8 n12 VDD VDD pmos
M20 n17 n12 VDD VDD pmos
M21 n2 n16 n1 GND nmos
M22 n2 n11 GND GND nmos
M23 n0 n6 n5 VDD pmos

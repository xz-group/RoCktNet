M1 cosn N1 IF VDD pmos
M2 cosn N2 IF VDD pmos
M3 cosp N1 IF VDD pmos
M4 cosp N2 IF VDD pmos
M5 sinn N4 IF VDD pmos
M6 sinn N3 IF VDD pmos
M7 sinp N4 IF VDD pmos
M8 sinp N3 IF VDD pmos
M9 N1 SMP VL VSS nmos
M10 N2 SMP VR VSS nmos
M11 N3 SMP VT VSS nmos
M12 N4 SMP VB VSS nmos
M13 IF IF VSS VSS nmos
M14 IF IF VSS VSS nmos

X1 n2 label_net_0 n15 amplifier
X2 n8 label_net_1 n19 amplifier
X3 n13 n6 label_net_2 amplifier
X4 n18 n4 label_net_3 amplifier
M1 n4 n9 n3 GND nmos
M2 n0 n0 n3 GND nmos
M3 n6 n11 VDD VDD pmos
M4 n2 n0 n3 GND nmos
I1 n5 n3
M5 n12 n15 n2 GND nmos
M6 n7 n7 VDD VDD pmos
I2 n1 n3
M7 n12 n19 n8 VDD pmos
M8 n10 n9 n3 GND nmos
M9 n11 n11 VDD VDD pmos
M10 n1 n1 n14 VDD pmos
M11 n8 n7 VDD VDD pmos
M12 n0 n21 n23 VDD pmos
M13 n17 n13 n6 VDD pmos
M14 n17 n18 n4 GND nmos
M15 n10 n24 n23 VDD pmos
M16 n7 n22 n23 GND nmos
M17 n11 n20 n23 GND nmos
M18 VDD label_net_4 n14 GND nmos
M19 VDD label_net_5 n16 GND nmos
M20 n5 n5 n16 VDD pmos

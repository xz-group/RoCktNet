M1 n4 n2 n1 n1 nmos
M2 n4 GND VDD VDD pmos
M3 n0 n3 n1 n1 nmos
M4 n2 GND n4 n4 nmos
M5 n0 GND n3 n3 nmos
M6 n0 GND VDD VDD pmos
M7 n1 label_net_0 GND GND nmos

R1 substrate N6 0.75
R2 N2 substrate 0.21
R3 substrate VSS 0.12
R4 substrate N7 0.57
C1 VDDE VSS 145p
C2 VSS VSSE 218p
C3 VSSE N7 52p
C4 VDD N6 19p
C5 VDD VSS 77p
C6 VDDE N2 53p
C7 VDDE VSSE 42p
C8 VDD VSSE 30p
C9 VDD VDDE 33p

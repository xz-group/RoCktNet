M1 N_L VIN_P N_TAIL VDD pmos
M2 N_R VIN_N N_TAIL VDD pmos
M3 IOUT_P DI_BAR N_L VDD pmos
M4 IOUT_P DI N_R VDD pmos
M5 N_TAIL VBB VDD VDD pmos
M6 IOUT_N DI_BAR N_R VDD pmos
M7 IOUT_N DI N_L VDD pmos

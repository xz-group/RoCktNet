M1 GND O1 GND GND nmos
M2 GND O2 GND GND nmos
M3 VDDV SA_WL RBL VDD pmos
M4 GND RBL GND GND nmos
M5 VDDV VDDV VDD VDD pmos
M6 VDD O2 VDD VDD pmos
M7 VDDV RBL RBL VDD pmos
M8 O2 O1 VDDV VDD pmos

LS IN N1 Ls
RS N1 OUT Rs
CS IN OUT Cs
Cox1 IN N2 Cox
RSi1 N2 GND Rsi
CSi1 N2 GND Csi
Cox2 OUT N3 Cox
RSi2 N3 GND Rsi
CSi2 N3 GND Csi

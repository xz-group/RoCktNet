M1 n1 label_net_0 n2 VDD pmos
M2 n6 label_net_1 n1 GND nmos
M3 n5 label_net_2 GND GND nmos
M4 n1 label_net_3 GND GND nmos
M5 n2 label_net_5 label_net_4 VDD pmos
M6 n1 label_net_6 n0 VDD pmos
M7 n0 label_net_8 label_net_7 VDD pmos
M8 n4 label_net_9 n3 VDD pmos
M9 n3 label_net_10 n4 VDD pmos
M10 n7 label_net_11 GND GND nmos
M11 n3 label_net_12 n1 GND nmos
M12 n4 label_net_13 n5 GND nmos
M13 n6 label_net_14 n4 VDD pmos
M14 n7 label_net_15 n4 VDD pmos

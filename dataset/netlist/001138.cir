M1 N1 N2 N4 N4 nmos
M2 N2 N1 N3 N3 nmos
M3 N4 N3 N5 N5 nmos
M4 N3 N4 N5 N5 nmos
M5 N5 PHI_SAE GND GND nmos

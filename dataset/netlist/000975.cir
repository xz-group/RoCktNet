M1 n3 n7 VDD VDD pmos
M2 n3 n7 GND GND nmos
M3 n0 n6 VDD VDD pmos
M4 n4 n1 n4 GND nmos
M5 n5 n2 n5 GND nmos
M6 n0 n6 GND GND nmos
M7 n4 label_net_0 n4 VDD pmos
M8 n0 label_net_1 n0 VDD pmos
M9 n3 label_net_2 n3 VDD pmos
M10 n5 label_net_3 n5 VDD pmos

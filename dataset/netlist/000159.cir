M1 VDD n14 VDD VDD pmos
M2 n7 n0 n2 GND nmos
M3 n7 label_net_0 VDD VDD pmos
M4 n6 label_net_1 VDD VDD pmos
M5 n3 n1 n2 GND nmos
M6 n9 n14 VDD VDD pmos
M7 n5 label_net_2 VDD VDD pmos
M8 n8 label_net_3 VDD VDD pmos
M9 n5 n1 n2 GND nmos
M10 n2 n12 n8 VDD pmos
M11 n4 n0 n2 GND nmos
M12 n2 n11 n6 VDD pmos
M13 n4 n12 n8 VDD pmos
M14 n2 n8 n10 VDD pmos
M15 n3 n11 n6 VDD pmos
M16 n2 n3 n9 VDD pmos
M17 n0 n3 n9 VDD pmos
M18 n1 n2 n10 VDD pmos

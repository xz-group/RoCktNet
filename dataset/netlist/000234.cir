M5 VDD VBIAS1 IBIAS IBIAS nmos
M4 VBIAS2 IBIAS VDD VDD pmos
M1 VBIAS2 VBIAS2 GND GND nmos
M3 VBIAS3 IBIAS VDD VDD pmos
M2 VBIAS3 VBIAS3 GND GND nmos

M1 VDD VDD VDD VDD pmos
M2 VDD VDD IN VDD pmos
M3 VDD VDD IN_B VDD pmos
M4 VDD VDD N1 VDD pmos
M5 VDD VDD VDD VDD pmos
M6 VDD VDD N0 GND nmos
M7 VDD VDD N0 GND nmos
M8 N0 EN N0 GND nmos
M9 VDD VDD N1 VDD pmos
M10 VDD VDD VDD GND nmos

I1 VDD n10
I2 n8 GND
I3 VDD n6
M1 n1 n0 VDD VDD pmos
M2 n3 n4 GND GND nmos
M3 n4 n4 GND GND nmos
M4 n1 n3 GND GND nmos
M5 n8 n8 n7 VDD pmos
M6 n2 n5 GND GND nmos
M7 n0 n2 VDD VDD pmos
M8 n9 n9 GND GND nmos
M9 n0 n6 n3 GND nmos
M10 n3 n8 n0 VDD pmos
M11 n5 n10 n10 VDD pmos
M12 n2 n2 VDD VDD pmos
M13 n6 n6 n9 GND nmos
M14 n5 n5 GND GND nmos
M15 n7 n7 VDD VDD pmos
M16 n4 n4 n5 VDD pmos
S1 VDD n3 switch_ideal

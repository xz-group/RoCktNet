M1 Io GND Ii1 VDD pmos
M2 N1 GND Ii1 GND nmos
M4 N0 GND Ii2 VDD pmos
M5 N1 N1 VDD VDD pmos
M8 Io N0 VSS GND nmos
M6 Io N1 VDD VDD pmos
M7 N0 N0 VSS GND nmos
M3 Io GND Ii2 GND nmos

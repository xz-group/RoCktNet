I1 VDD N0
I2 N1 GND
M1 N2 N2 VDD VDD pmos
I3 N4 GND
M2 N3 LABEL_NET_0 N1 GND nmos
M3 N3 LABEL_NET_1 N4 GND nmos
M4 N3 N3 VDD VDD pmos
M5 N2 LABEL_NET_2 N1 GND nmos
M6 N2 N4 N4 GND nmos
M7 N0 LABEL_NET_3 N4 GND nmos
M8 N0 LABEL_NET_4 N1 GND nmos

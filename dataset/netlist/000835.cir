I1 N3 GND
I2 N1 GND
I3 N6 GND
I4 N0 GND
I5 N2 GND
I6 N5 GND
Q10 VDD Y1_N N3 npn
Q12 VDD Y2_N N6 npn
Q16 VDD Y4_N N2 npn
Q14 VDD Y3_N N1 npn
Q18 VDD Y5_N N5 npn
Q13 ICOMP Y3_P N1 npn
Q19 ICOMP Y6_P N0 npn
Q9 ICOMP Y1_P N3 npn
Q17 ICOMP Y5_P N5 npn
Q20 VDD Y6_N N0 npn
Q11 ICOMP Y2_P N6 npn
Q15 ICOMP Y4_P N2 npn

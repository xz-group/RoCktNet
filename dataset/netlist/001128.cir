M1 N0 N0 N6 VDD pmos
M2 N5 LABEL_NET_0 N1 GND nmos
M3 N4 LABEL_NET_1 N2 GND nmos
M4 N3 LABEL_NET_2 N1 GND nmos
M5 N0 LABEL_NET_3 N2 GND nmos
M6 N5 N5 N6 VDD pmos
M7 N4 N5 N6 VDD pmos
M8 N3 N3 N6 VDD pmos
I1 N2 GND
I2 N1 GND

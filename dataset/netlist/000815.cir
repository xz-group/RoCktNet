M1 n1 label_net_0 n2 GND nmos
M2 n2 label_net_1 GND GND nmos
M3 n0 label_net_2 n2 GND nmos
M4 n0 label_net_3 VDD VDD pmos
M5 n1 label_net_4 VDD VDD pmos

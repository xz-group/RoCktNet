I_fine VDD N2
I_coarse VDD N4
M1c N7 Vfine_p N2 VDD pmos
M9a I9 N7 GND GND nmos
M6c N0 Vcoarse_n N4 VDD pmos
M8c N0 N0 GND GND nmos
M10a I10 N0 GND GND nmos
M9b I9 N3 GND GND nmos
M10b I10 N1 GND GND nmos
M5c N3 Vcoarse_p N4 VDD pmos
M2c N1 Vfine_n N2 VDD pmos
M7c N3 N3 GND GND nmos
M3c N7 N7 GND GND nmos
M4c N1 N1 GND GND nmos

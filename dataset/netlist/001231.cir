M4 OUT1 Vcasc N1 GND nmos
M1 OUT2 Vcasc N2 GND nmos
M3 N1 Vin N3 GND nmos
M2 N2 Vref N3 GND nmos
I1 N3 GND

M1 n6 n2 VDD VDD pmos
M2 n0 label_net_0 n1 VDD pmos
M3 n1 label_net_1 VDD VDD pmos
M4 n4 label_net_2 n1 VDD pmos
M5 n2 n2 VDD VDD pmos
M6 n5 label_net_3 n6 VDD pmos
M7 n2 label_net_4 n3 GND nmos
M8 n0 n0 GND GND nmos
M9 n3 n0 GND GND nmos
M10 n4 n4 GND GND nmos
M11 n7 n4 GND GND nmos
M12 n5 label_net_5 n7 GND nmos
Q1 n0 label_net_6 n4 npn

M5 outP clk_b VDD VDD pmos
M6 outM clk_b VDD VDD pmos
M3 tail clk N0 GND nmos
M4 N0 bias GND GND nmos
M1 tail clk VDD VDD pmos
M2 outP outM clk_b VDD pmos
M7 outP Vref tail GND nmos
M8 outM inP tail GND nmos

M1 N0 N0 N1 VDD pmos
M2 N0 N0 GND GND nmos
M3 Vctrl N0 Vmod GND nmos
M4 Vmod N0 Vctrl GND nmos
M5 Vctrl N0 Vctrl GND nmos
M6 Vctrl N0 Vctrl GND nmos
M7 N0 N0 GND GND nmos
M8 N0 N0 N1 VDD pmos

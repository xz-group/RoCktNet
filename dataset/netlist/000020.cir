M1 GND label_net_0 n2 GND nmos
M2 n4 n7 VDD VDD pmos
M3 n5 label_net_1 n5 GND nmos
M4 n0 label_net_2 GND GND nmos
M5 n3 label_net_3 n0 GND nmos
M6 n4 n4 n2 GND nmos
M7 GND label_net_4 n1 GND nmos
M8 n4 n7 VDD VDD pmos
M9 n3 n6 VDD VDD pmos
M10 n3 label_net_5 VDD VDD pmos
M11 n4 label_net_6 n2 GND nmos
M12 n3 label_net_7 n0 GND nmos
M13 n3 n3 n1 GND nmos
M14 n4 n4 n5 GND nmos
M15 n5 n4 n5 GND nmos
M16 n1 label_net_8 GND GND nmos
M17 n1 n3 n1 GND nmos
M18 n2 label_net_9 GND GND nmos
M19 n0 label_net_10 n0 GND nmos
M20 n5 label_net_11 n5 GND nmos

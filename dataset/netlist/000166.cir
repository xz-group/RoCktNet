A1 (IN- IN+ OP OM) amplifier
C2 IN- OP CiB
C1 IN+ OM CiB
C4 IN- IN1 CiA
C3 IN+ IN2 CiA

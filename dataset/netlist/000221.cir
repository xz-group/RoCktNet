R1 GND in1 50
R2 GND in2 50
Q2 GND in1 out1 npn
Q1 GND in2 out2 npn
I2 out1 VEE
I1 out2 VEE

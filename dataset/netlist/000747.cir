M11 N2 N1 GND GND nmos
M13 BL N2 VDD VDD pmos
M10 N1 N1 GND GND nmos
M1 BL BL GND GND nmos
M14 N1 BL GND GND nmos
IC BL GND
Ibias VDD N1
M12 N2 N2 VDD VDD pmos

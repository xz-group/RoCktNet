M1 VO_MINUS VI_PLUS N1 GND nmos
M2 VO_MINUS VDD VDD VDD pmos
M3 N2 VREPLICA GND GND nmos
M4 VO_PLUS RST VDD VDD pmos
M5 N1 VDD N2 GND nmos
M6 VO_PLUS VI_MINUS N1 GND nmos
M7 VO_PLUS VC VDD VDD pmos
M8 VO_MINUS VC VDD VDD pmos

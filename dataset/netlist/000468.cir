IB N2 N0
M23 N3 N3 N2 VDD pmos
M21 N3 N0 GND GND nmos
M22 N1 v1 GND GND nmos
M18 N0 N0 GND GND nmos
M17 N0 v1 GND GND nmos
M24 N1 N3 N2 VDD pmos

M1 n4 n0 GND GND nmos
M2 n2 n0 GND GND nmos
M3 n6 label_net_0 n4 GND nmos
M4 n7 label_net_1 n1 VDD pmos
M5 n1 label_net_2 n2 GND nmos
M6 n6 label_net_3 n3 VDD pmos
M7 n8 n0 GND GND nmos
M8 n1 n5 VDD VDD pmos
M9 n7 label_net_4 n8 GND nmos
M10 n3 label_net_5 n2 GND nmos
M11 n3 n5 VDD VDD pmos

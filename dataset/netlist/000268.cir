M1 io_plus Vi_minus GND GND nmos
M2 io_minus Vi_plus GND GND nmos
M3 io_plus Vb VDD VDD pmos
M4 io_minus Vb VDD VDD pmos

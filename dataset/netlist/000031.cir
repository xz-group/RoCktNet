M1 n2 n5 n1 GND nmos
M2 n5 n0 n3 GND nmos
M3 n3 n0 n1 GND nmos
M4 n5 n0 n4 VDD pmos
M5 n3 n2 n1 GND nmos
M6 n4 n2 VDD VDD pmos
M7 n2 n5 VDD VDD pmos
M8 n4 n0 VDD VDD pmos

M1 n4 VDD n3 VDD pmos
M2 n6 n0 GND GND nmos
M3 n0 n1 VDD VDD pmos
M4 n6 VDD n2 VDD pmos
M5 label_net_0 n0 n0 VDD pmos
M6 GND label_net_3 n5 VDD pmos
M7 VDD VDD n1 VDD pmos
M8 n1 VDD n0 VDD pmos
M9 n1 n0 VDD VDD pmos
M10 n4 n1 GND GND nmos
M11 n5 n0 n1 VDD pmos
M12 n5 n1 n0 VDD pmos
M13 n0 VDD VDD VDD pmos
M14 label_net_5 n1 GND VDD pmos

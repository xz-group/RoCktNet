M1 n1 label_net_0 GND GND nmos
M2 n0 label_net_2 label_net_1 VDD pmos
M3 label_net_3 label_net_4 GND GND nmos
M4 n0 GND label_net_5 VDD pmos
M5 n1 label_net_6 n0 VDD pmos
M6 n1 GND label_net_3 GND nmos

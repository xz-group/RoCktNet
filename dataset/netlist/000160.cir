M1 N_OUT Vip N_TAIL1 VDD pmos
M2 N_MIRROR Vref N_TAIL1 VDD pmos
M3 N_MIRROR Vref N_TAIL2 VDD pmos
M4 N_OUT Vin N_TAIL2 VDD pmos
M5 N_MIRROR N_MIRROR VSS VSS nmos
M6 N_MIRROR N_MIRROR VSS VSS nmos
M7 N_OUT N_MIRROR VSS VSS nmos
M8 N_OUT Vcmfb VDD VDD pmos
M9 Vb Vb VDD VDD pmos
M10 N_TAIL1 Vb VDD VDD pmos
M11 N_TAIL2 Vb VDD VDD pmos
I1 Vb VSS Iss

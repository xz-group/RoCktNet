M7 N_M7_D N_M7_D VDD VDD pmos
M8 v_out N_M7_D VDD VDD pmos
M6 N_M7_D v_in1 N_TAIL GND nmos
M2 v_out v_in2 N_TAIL GND nmos
M3 N_I0_BOT v_out N_TAIL GND nmos
M5 N_TAIL N_I0_BOT GND GND nmos
M9 v_in1 v_in1 N_M9_S GND nmos
M1 v_in2 v_in2 N_M1_S GND nmos
M4 i_out v_out N_M4_S GND nmos
C v_out GND
I0 VDD N_I0_BOT
I1 N_M9_S GND
I2 N_M1_S GND
I3 N_M4_S GND

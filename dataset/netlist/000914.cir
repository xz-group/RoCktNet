M1 N1 N3 VDD VDD pmos
M2 N4 GND VDD VDD pmos
M3 N2 N3 GND GND nmos
M4 N3 N1 VDD VDD pmos
M5 GND Vni_or_Vpi VDD VDD pmos
M6 Vqn_or_Vqp N2 VDD VDD pmos
M7 N2 N3 VDD VDD pmos
M8 N3 GND GND GND nmos
M9 N4 GND GND GND nmos
M10 N1 N4 GND GND nmos
M11 Vqn_or_Vqp N2 GND GND nmos
M12 GND Vni_or_Vpi GND GND nmos

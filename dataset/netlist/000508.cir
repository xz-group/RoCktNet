M1 Ip N3 GND GND nmos
M2 In N0 GND GND nmos
M3 Ic N2 GND GND nmos
C1 N0 VDD w_DD
C2 N0 Vn w/2
C3 N3 VDD w_DD
C4 N0 Vn w/2
C5 N2 Vp w/2
C6 Vn N2 w/2
C7 N3 Vp w/2
C8 N2 VDD w_DD
C9 N3 Vp w/2

I1 N2 GND
I2 N4 GND
M3 VDD VDD N3 GND nmos
M5 Dout Din_bar N2 GND nmos
M7 VDD VDD Dout GND nmos
M1 N3 Din N4 GND nmos
M4 VDD VDD Dout_bar GND nmos
M8 VDD VDD Dout_bar GND nmos
M6 Dout_bar Dout_bar N2 GND nmos
M2 Dout_bar Din_bar N4 GND nmos

M1 Q Q_bar N2 VDD pmos
M2 Q CLK GND GND nmos
M3 Q_bar CLK GND GND nmos
M4 Q_bar D N2 VDD pmos
M5 Q D_bar N2 VDD pmos
M6 Q_bar Q N2 VDD pmos

M1 V_OM N8 N4 GND nmos
M2 V_OP N6 N4 GND nmos
M3 N8 V_IM N7 VDD pmos
M4 N8 N8 N4 GND nmos
M5 N6 N6 N4 GND nmos
M6 N6 V_IP N7 VDD pmos
M7 V_OP V_CM VDD VDD pmos
M8 V_OM V_CM VDD VDD pmos
M9 N7 N1 VDD VDD pmos
M10 V_OM N2 VDD VDD pmos
M11 V_OP N1 VDD VDD pmos

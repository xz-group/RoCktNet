M1 b f GND GND nmos
M2 a e VDD VDD pmos
M3 c a VDD VDD pmos
M4 e c VDD VDD pmos
M5 f d e GND nmos
M6 d b d GND nmos
M7 b V_CTRL_BAR a VDD pmos
M8 d e c VDD pmos
M9 e V_CTRL_BAR e VDD pmos
M10 a V_CTRL b GND nmos

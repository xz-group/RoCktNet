M1 N1 Vx N3 VDD pmos
M2 N2 Vy N3 VDD pmos
M3 N1 N1 VSS VSS nmos
M4 N2 N2 VSS VSS nmos
M5 N5 N1 VSS VSS nmos
M6 N4 N4 VSS VSS nmos
M7 Vo1 N4 N5 VSS nmos
M8 N7 N2 VSS VSS nmos
M9 N6 N6 VSS VSS nmos
M10 Vo2 N6 N7 VSS nmos
M11 Vo1 Vo1 VDD VDD pmos
M12 Vo2 Vo1 VDD VDD pmos
C Vo1 Vo2
I1 VDD N6
I2 VDD N4
I5 VDD N3

Q1 N1 Vin N3 npn
Q2 N2 Vinb N4 npn
Q3 Vob LO N1 npn
Q4 Vo LOb N1 npn
Q5 Vob LOb N2 npn
Q6 Vo LO N2 npn
R1 VCC Vob RL
R2 VCC Vo RL
R3 N4 N5 RE
R4 N3 N5 RE
C1 Vo VCC CL
C2 Vob VCC CL
I N5 VEE

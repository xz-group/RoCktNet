mm5 cmfb cmfb GND GND nmos
mm2 cmfb Vcm N3 VDD pmos
mm7 N3 b1 VDD VDD pmos
mm6 N5 N5 GND GND nmos
mm8 N1 b1 VDD VDD pmos
mm3 cmfb Vcm N1 VDD pmos
mm4 N5 Vout_minus N1 VDD pmos
mm1 N5 Vout_plus N3 VDD pmos

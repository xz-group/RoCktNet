I1 VDD N1
I2 VDD N2
I3 N3 GND
I4 N4 GND
R N1 N2
M1 N3 VIP N1 VDD pmos
M2 N4 VIM N2 VDD pmos
M3 N1 N3 GND GND nmos
M4 N2 N4 GND GND nmos
M5 VDD BIAS IOM GND nmos
M6 IOM N3 GND GND nmos
M7 VDD BIAS IOP GND nmos
M8 IOP N4 GND GND nmos

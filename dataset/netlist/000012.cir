M1 n1 n0 VDD VDD pmos
M2 n1 n0 n2 VDD pmos
M3 n2 label_net_1 VDD VDD pmos
M4 label_net_2 label_net_3 n1 VDD pmos

I1 N3 GND
I2 N0 GND
M4 VOUT N1 VDD VDD pmos
M1 N1 VIN N3 GND nmos
M3 N1 N1 VOUT VDD pmos
M5 N1 VDCB N0 GND nmos
M6 VOUT VDC N0 GND nmos
M2 VOUT LABEL_NET_5 N3 GND nmos

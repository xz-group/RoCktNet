I1 VDD N0
M1 N11 N5 N4 GND nmos
M2 N0 N2 GND GND nmos
M3 N13 N13 VDD VDD pmos
M4 N8 N8 N6 VDD pmos
M5 N8 in N7 GND nmos
M6 H_bar N12 GND GND nmos
M7 N7 N3 GND GND nmos
M8 N5 N6 VDD VDD pmos
M9 N11 N11 VDD VDD pmos
M10 H N13 VDD VDD pmos
M11 N6 Vhigh N7 GND nmos
M12 N13 N0 N4 GND nmos
M13 N5 N10 GND GND nmos
M14 H_bar N11 VDD VDD pmos
M15 N0 N2 GND GND nmos
M16 H N0 GND GND nmos
M17 N0 N8 VDD VDD pmos
M18 N6 N6 VDD VDD pmos
M19 N4 N12 GND GND nmos

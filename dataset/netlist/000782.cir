V94 VIN VSSA acm=vin
R51 VIN vgs Rs
C25 vgs Vo Cgs
I0 vgs Vo idc=gm*vgs
R43 Vo VSSA RL
C24 Vo VSSA CL

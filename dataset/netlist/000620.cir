M1 GND CK GND GND nmos
M2 GND N0b GND GND nmos
M3 GND GND GND GND nmos
M4 VDD GND GND GND nmos
M5 N2 N0b GND GND nmos
M6 GND N0a GND GND nmos
M7 VDD N0b VDD VDD pmos
M8 N0b N2 VDD VDD pmos
M9 GND N0a VDD VDD pmos
M10 N5 Q GND GND nmos
M11 GND CK VDD VDD pmos
M12 VDD N2 GND VDD pmos
M13 GND GND VDD VDD pmos
M14 D GND N0a VDD pmos
M15 GND GND GND GND nmos
M16 GND N1a GND GND nmos
M17 GND VDD GND VDD pmos
M18 GND N0b VDD VDD pmos
M19 D GND N0b VDD pmos
M20 N0b GND N5 GND nmos
M21 D GND N0b GND nmos
M22 D GND N0a GND nmos

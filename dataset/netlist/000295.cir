I1 N2 GND
M1 OUT_PLUS IN_MINUS N4 VDD pmos
M2 N3 N11 GND GND nmos
M3 N4 N2 VDD VDD pmos
M4 OUT_MINUS OUT_MINUS N9 GND nmos
M5 N12 OUT_PLUS N0 GND nmos
M6 OUT_PLUS OUT_PLUS N6 GND nmos
M7 N12 OUT_MINUS N0 GND nmos
M8 OUT_MINUS N11 GND GND nmos
M9 N0 N0 GND GND nmos
M10 N2 N2 VDD VDD pmos
M11 OUT_PLUS N11 GND GND nmos
M12 OUT_MINUS IN_PLUS N4 VDD pmos
M13 N7 CTRL N3 VDD pmos
M14 N3 VDD N10 GND nmos
M15 N7 VDD N6 VDD pmos
M16 N7 VDD N3 GND nmos
M17 N3 CTRL N3 GND nmos
M18 N10 VDD N9 GND nmos

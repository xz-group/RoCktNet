M1 n0 n1 VDD VDD pmos
M2 n0 n2 VDD VDD pmos
M3 n1 n0 VDD VDD pmos
M4 n0 n5 GND GND nmos
M5 n1 n4 GND GND nmos
M6 n1 n3 VDD VDD pmos
M7 label_net_2 label_net_0 n5 GND nmos
M8 n4 label_net_4 label_net_3 GND nmos
M9 label_net_5 VDD n2 GND nmos
M10 label_net_6 VDD n3 VDD pmos

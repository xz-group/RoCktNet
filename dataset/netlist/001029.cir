I1 VDD N_BIAS
M1 CP_output N_PMIRROR VDD VDD pmos
M3 N_PMIRROR N_PMIRROR VDD VDD pmos
M2 CP_output N_BIAS N_SW2 GND nmos
M4 N_BIAS N_BIAS N_SRC1 GND nmos
M5 N_SRC1 VDD GND GND nmos
M8 N_PMIRROR N_BIAS N_SW1 GND nmos
M6 N_SW1 up_bar GND GND nmos
M7 N_SW2 down_bar GND GND nmos

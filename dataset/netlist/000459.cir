R1 VDD Vo gmp1
R2 VDD Vo GL
I1 Vo GND gmn3Vin
C1 Vo GND SCL
I2 Vo GND gmn1Vo

M1 N9 GND N6 GND nmos
M2 Vout GND N11 GND nmos
I1 VDD N10
M3 N7 GND N3 GND nmos
M4 N13 N0 VDD VDD pmos
M5 N6 N9 GND GND nmos
M6 N5 N9 GND GND nmos
M7 N3 N7 GND GND nmos
M8 N11 N7 GND GND nmos
M9 N0 GND N5 GND nmos
M10 N2 N0 VDD VDD pmos
M11 N9 V_MINUS N10 VDD pmos
M12 Vout Vcp N13 VDD pmos
M13 N0 Vcp N2 VDD pmos
M14 N7 V_PLUS N10 VDD pmos

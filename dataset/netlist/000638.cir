Q1 N_E_LEFT IBUF N_Q1_E npn
Q2 N_BIAS N_BIAS N_Q2_E npn
Q3 N_Q7_E DINN N_E_RIGHT npn
Q4 N_R2 N_Q7_B N_Q7_E npn
Q5 VDD VDD N_BIAS npn
Q6 IBUF IBUF N_Q6_E npn
Q7 N_R2 N_Q7_B N_Q7_E npn
Q8 N_E_RIGHT IBUF N_Q8_E npn
Q9 N_E_LEFT IBUF N_Q9_E npn
Q10 N_R4 N_Q15_B N_Q15_E npn
Q11 N_Q15_E DINP N_E_LEFT npn
Q12 N_Q7_E DINN N_E_RIGHT npn
Q13 N_E_RIGHT IBUF N_Q13_E npn
Q14 N_Q15_E DINP N_E_LEFT npn
Q15 N_R4 N_Q15_B N_Q15_E npn
Q16 N_Q16_C IBUF N_Q16_E npn
R1 N_Q8_E GND 30
R2 VDD N_R2 55
R3 N_Q6_E GND 30
R4 VDD N_R4 55
R5 N_Q13_E GND 30
R6 N_Q9_E GND 30
R7 N_Q1_E GND 30
R8 N_BIAS N_Q7_B 5
R9 N_Q16_E GND 30
R10 N_Q2_E N_Q16_C 90
R11 N_BIAS N_Q15_B 5
R12 N_R4 OUTN 5
R13 N_R2 OUTP 5
R14 N_E_LEFT N_MID 10
R15 N_MID N_E_RIGHT 10
C1 N_BIAS GND 1.1p

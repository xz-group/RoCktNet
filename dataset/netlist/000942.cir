M1 N1 IN VDD VDD pmos
M2 OUT IN VDD VDD pmos
M3 N1 N1 VSS VDD pmos
M4 OUT N1 GND VDD pmos

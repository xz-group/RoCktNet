M1 SO SON N1 GND nmos
M2 SO SON VDD VDD pmos
M3 SON SO N2 GND nmos
M4 SON SO VDD VDD pmos
M5 N1 INN com GND nmos
M6 N2 INP com GND nmos
M7 SO EN VDD VDD pmos
M8 SON EN VDD VDD pmos
M9 com EN GND GND nmos

M1 Q QB VDD VDD pmos
M2 QB Q VDD VDD pmos
M3 QB Q GND GND nmos
M4 BLB QB pred GND nmos
M5 Q QB GND GND nmos
M6 BLB 0 QB GND nmos
M7 BL 0 Q GND nmos
M8 1 1 BL GND nmos
M9 BL Q predB GND nmos
M10 1 1 BLB GND nmos

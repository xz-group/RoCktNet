M1 N2 LABEL_NET_0 N5 GND nmos
M2 N4 LABEL_NET_1 N5 GND nmos
M3 N0 VP N4 GND nmos
M4 N0 LABEL_NET_3 VDD VDD pmos
M5 N3 LABEL_NET_4 N2 GND nmos
M6 N1 LABEL_NET_5 N2 GND nmos
M7 VDD Vamp N4 GND nmos
M8 N3 N6 N0 VDD pmos
M9 N2 LABEL_NET_7 N5 GND nmos
M10 N0 VN N4 GND nmos
M11 N0 LABEL_NET_9 VDD VDD pmos
M12 N1 N7 N0 VDD pmos
A1 (N0 N6 N7) amplifier
A2 (N2 LABEL_NET_10) amplifier

M1 X0 X1 VDD VDD pmos
M2 X1 X0 VDD VDD pmos
M3 X0 X1 GND GND nmos
M4 X1 X0 GND GND nmos
M5 X0 CK D GND nmos
M6 D_prime CK X1 GND nmos

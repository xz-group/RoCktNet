I1 N_BIAS GND 10u
M12 N_BIAS N_BIAS VDD VDD pmos
M16 N_OUT1_L N_BIAS VDD VDD pmos
M15 N_TAIL1 N_BIAS VDD VDD pmos
M7 N_OUT1_R N_BIAS VDD VDD pmos
M2 N_D1_L in N_TAIL1 VDD pmos
M1 N_D1_R Vlow N_TAIL1 VDD pmos
M10 N_D1_L N_D1_L GND GND nmos
M4 N_OUT1_L N_D1_L GND GND nmos
M17 N_D1_R N_D1_R GND GND nmos
M5 N_OUT1_R N_D1_R GND GND nmos
M18 L N_BIAS VDD VDD pmos
M13 N_TAIL2 N_BIAS VDD VDD pmos
M6 L_BAR N_BIAS VDD VDD pmos
M14 N_D2_L N_OUT1_L N_TAIL2 VDD pmos
M19 N_D2_R N_OUT1_R N_TAIL2 VDD pmos
M11 N_D2_L N_D2_L GND GND nmos
M3 L N_D2_L GND GND nmos
M9 N_D2_R N_D2_R GND GND nmos
M8 L_BAR N_D2_R GND GND nmos

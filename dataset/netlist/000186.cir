M2 Vref Ibias GND GND nmos
M1 Ibias Ibias GND GND nmos
M10 Vbias2 Vbias3 N7 VDD pmos
M3 Vbias3 Ibias GND GND nmos
M12 Vbias1 Vbias3 N1 VDD pmos
M4 Vbias2 Ibias GND GND nmos
I1 VDD Ibias
M5 Vbias1 Vbias1 GND GND nmos
M9 N7 Vbias2 VDD VDD pmos
M11 N1 Vbias2 VDD VDD pmos
M7 Vref Vref VDD VDD pmos
M8 Vbias3 Vbias3 VDD VDD pmos

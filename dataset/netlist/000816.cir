Ib N0 GND
Mi2 VO V_MINUS N0 GND nmos
Mi3 N1 N1 N2 VDD pmos
Mi1 N1 V_PLUS N0 GND nmos
Mi4 VO N1 N2 VDD pmos

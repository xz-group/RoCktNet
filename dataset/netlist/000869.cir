M1 n1 n3 n4 VDD pmos
M2 n2 label_net_0 n4 VDD pmos
M3 n1 label_net_1 n0 GND nmos
M4 n2 label_net_2 n0 GND nmos
M5 n3 label_net_3 VDD VDD pmos
M6 n3 n2 GND GND nmos

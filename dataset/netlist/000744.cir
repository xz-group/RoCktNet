M2 OUT1 BL GND GND nmos
IREF OUT1 GND
IB_2 VDD OUT1
M1 BL BL GND GND nmos
IC BL GND
IB_1 VDD BL

M1 N2 OUT N1 GND nmos
M2 BUF_OUT OUT GND GND nmos
M3 N1 IN GND GND nmos
M4 N2 BIAS VDD VDD pmos
M5 OUT N0 GND GND nmos
M6 N0 N2 GND GND nmos
M7 OUT BIAS VDD VDD pmos
M8 N0 BIAS VDD VDD pmos

I1_prime N2 GND
I1 N3 GND
I2 VDD N0
M4 out_minus out_minus VDD VDD pmos
I2_prime VDD N4
M3_prime N2 in_minus VDD VDD pmos
M1_prime N4 N2 GND GND nmos
M4_prime out_plus out_plus VDD VDD pmos
M2_prime out_plus N4 N2 GND nmos
M1 N0 N3 GND GND nmos
M3 N3 in_plus VDD VDD pmos
M2 out_minus N0 N3 GND nmos

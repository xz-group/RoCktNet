M1 N8 SEL_BAR GND GND nmos
M2 OUT_BAR REF N3 GND nmos
M3 OUT_BAR VCO N4 GND nmos
M4 OUT REF_BAR N7 GND nmos
M5 OUT VCO N8 GND nmos
M6 N4 SEL_BAR GND GND nmos
M7 N3 SEL GND GND nmos
M8 N7 SEL GND GND nmos
M9 N5 SEL_BAR VCTRL VCTRL pmos
M10 N6 SEL VCTRL VCTRL pmos
M11 OUT VCO N6 VCTRL pmos
M12 OUT_BAR REF N1 VCTRL pmos
M13 OUT_BAR VCO N2 VCTRL pmos
M14 N1 SEL_BAR VCTRL VCTRL pmos
M15 N2 SEL VCTRL VCTRL pmos
M16 OUT REF_BAR N5 VCTRL pmos

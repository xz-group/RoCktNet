Ibias2 N3 GND
M4n Vout N2 GND GND nmos
M1p N2 Vin_plus N0 VDD pmos
M2p Vout Vin_minus N0 VDD pmos
M6p N3 N3 VDD VDD pmos
M5p N0 N3 VDD VDD pmos
M3n N2 N2 GND GND nmos

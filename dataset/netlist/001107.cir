Ibias N5 GND
M9 v_o B GND GND nmos
M5 N1 VDD A GND nmos
M10 v_o N4 VDD VDD pmos
M4 v_plus N1 GND GND nmos
M6 B VDD v_plus GND nmos
MT N12 N4 VDD VDD pmos
MB1 N5 N5 VDD VDD pmos
M7 N1 N4 VDD VDD pmos
M3 A N1 GND GND nmos
M2 v_plus v_plus N12 VDD pmos
M8 B N4 VDD VDD pmos
M1 A v_minus N12 VDD pmos
CC v_o N8
MC N8 VDD v_plus GND nmos

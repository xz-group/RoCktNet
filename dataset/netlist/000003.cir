M1 V_dn_2_minus V_up_2_plus N5 GND nmos
M2 N5 PHI_COMP GND GND nmos
M3 V_dn_2_plus V_up_2_minus N5 GND nmos
M4 V_up_2_plus V_dn_2_minus N4 VDD pmos
M5 V_up_2_minus V_dn_2_plus N4 VDD pmos
M6 N4 PHI_COMP_B VDD VDD pmos

M1 N1 data VDD VDD pmos
M2 BLB data 1 GND nmos
M3 BL 1 1 VDD pmos
M4 data N1 VDD VDD pmos
M5 BL 0 N1 VDD pmos
M6 data N1 GND GND nmos
M7 N1 data GND GND nmos
M8 BLB 0 data VDD pmos
M9 BLB 1 1 VDD pmos
M10 BL N1 0 GND nmos

M1 n2 label_net_0 VDD VDD pmos
M2 GND label_net_1 GND GND nmos
M3 label_net_2 n2 VDD VDD pmos
M4 n2 n0 n3 GND nmos
M5 n0 label_net_3 VDD VDD pmos
M6 n1 VDD GND GND nmos
M7 n2 n0 VDD VDD pmos
M8 n0 n2 n0 GND nmos
M9 n3 VDD GND GND nmos
M10 n1 label_net_4 n1 n1 pmos
M11 n1 n1 GND n1 nmos
M12 n1 label_net_5 n1 GND nmos
M13 n1 label_net_6 n1 n1 nmos

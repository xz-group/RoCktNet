Mp1 N_L1 clkbar VDD VDD pmos
Mp2 N_L2 clkbar VDD VDD pmos
Mp3 N_R1 clk VDD VDD pmos
Mp4 N_R2 clk VDD VDD pmos
Mn1 N_L1 N_L2 N_TL1 GND nmos
Mn2 N_L2 N_L1 N_TL1 GND nmos
Mn3 N_TL1 clkbar GND GND nmos
Mn4 N_L1 N_R1 N_TL2 GND nmos
Mn5 N_L2 N_R2 N_TL2 GND nmos
Mn6 N_TL2 clk GND GND nmos
Mn7 N_R1 N_R2 N_TR1 GND nmos
Mn8 N_R2 N_R1 N_TR1 GND nmos
Mn9 N_TR1 clk GND GND nmos
Mn10 N_R1 N_L2 N_TR2 GND nmos
Mn11 N_R2 N_L1 N_TR2 GND nmos
Mn12 N_TR2 clkbar GND GND nmos

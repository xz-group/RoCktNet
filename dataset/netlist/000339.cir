I1 VDD GND
M1 N2 DWB DW GND nmos
M2 N6 N6 VDD VDD pmos
M3 DW GND GND GND nmos
M4 N5 N5 VDD VDD pmos
M5 From_PUMP2 From_PUMP2 GND GND nmos
M6 PLLOUT From_PUMP2 GND GND nmos
M7 N5 UPB N7 GND nmos
M8 N6 UP N7 GND nmos
M9 N7 GND GND UPB nmos
M10 N4 N4 VDD VDD pmos
M11 From_PUMP2 N4 VDD VDD pmos
M12 GND GND GND GND nmos
M13 N2 N2 VDD VDD pmos
M14 N4 DW N4 GND nmos
M15 PLLOUT N6 VDD VDD pmos

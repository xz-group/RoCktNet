MP1 NET_MP1_D EnableB VDD VDD pmos
MP2 NET_MP2_D EnableB VDD VDD pmos
MP3 NET_MP3_D EnableB VDD VDD pmos
MP4 NET_MP4_D EnableB VDD VDD pmos
Mcm1 on on NET_MP1_D VDD pmos
Mcm2 on op NET_MP2_D VDD pmos
Mcm3 op on NET_MP3_D VDD pmos
Mcm4 op op NET_MP4_D VDD pmos
Mip1 on ip NET_MN1_D GND nmos
Mip2 on ip NET_MN2_D GND nmos
Min2 op in NET_MN3_D GND nmos
Min1 op in NET_MN4_D GND nmos
MN1 NET_MN1_D Enable GND GND nmos
MN2 NET_MN2_D Enable GND GND nmos
MN3 NET_MN3_D Enable GND GND nmos
MN4 NET_MN4_D Enable GND GND nmos

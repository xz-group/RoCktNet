M1 n0 label_net_0 VDD VDD pmos
M2 n1 n0 VDD VDD pmos
M3 n1 label_net_1 GND GND nmos
M4 n0 label_net_2 GND GND nmos

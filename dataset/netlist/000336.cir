M1 n2 label_net_0 n1 GND nmos
M2 n3 label_net_1 n0 GND nmos
M3 n2 label_net_2 n0 GND nmos
M4 n3 n3 VDD VDD pmos
M5 n3 label_net_3 n1 GND nmos
M6 n2 n5 label_net_4 VDD pmos
M7 label_net_5 n4 n0 GND nmos
M8 n2 n2 label_net_6 VDD pmos
M9 n3 n5 VDD VDD pmos
M10 n1 n4 label_net_7 GND nmos

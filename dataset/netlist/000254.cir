M1 N0 N0 VDD VDD pmos
M2 N1 N1 VDD VDD pmos
M3 N0 N0 VDD VDD pmos
M4 N3 Vbias GND GND nmos
M5 N2 N4 GND GND nmos
M6 N2 N1 VDD VDD pmos
M7 N4 N0 VDD VDD pmos
M8 N1 VPLUS N3 GND nmos
M9 Vout N2 VDD VDD pmos
M10 N0 N1 VDD VDD pmos
M11 Vout N2 GND GND nmos
M12 N4 N4 GND GND nmos
M13 N0 VMINUS N3 GND nmos

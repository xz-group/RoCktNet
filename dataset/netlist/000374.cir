I1 n1 label_net_0
M1 n6 n2 label_net_1 GND nmos
M2 n1 n1 label_net_2 VDD pmos
M3 n4 label_net_3 n5 VDD pmos
M4 n0 label_net_4 n3 VDD pmos
M5 n5 n1 label_net_5 VDD pmos
M6 n2 label_net_6 n5 VDD pmos
M7 n7 n4 label_net_7 GND nmos
M8 n6 n6 label_net_8 VDD pmos
M9 n4 n4 label_net_9 GND nmos
M10 n2 n2 label_net_10 GND nmos
M11 n3 n6 label_net_11 VDD pmos
M12 n0 label_net_12 n7 GND nmos

M1 n0 n4 GND GND nmos
M2 label_net_0 n4 GND GND nmos
M3 n3 n0 GND GND nmos
M4 n4 n3 GND GND nmos
M5 n0 label_net_1 VDD VDD pmos
M6 n3 n1 VDD VDD pmos
M7 n4 n1 VDD VDD pmos
M8 n3 label_net_2 n4 GND nmos

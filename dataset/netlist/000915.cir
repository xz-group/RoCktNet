M2d N0 Vbias_en_bar GND GND nmos
M5 N1 Vbias_en GND GND nmos
M8 cm i_minus N0 GND nmos
M1d cm i_plus N0 GND nmos
M2 N1 Vbias_en GND GND nmos
M6 N0 Vbias_en_bar GND GND nmos
M7 o_plus i_minus N1 GND nmos
M3 o_minus cmfb N4 VDD pmos
M9 o_plus cmfb N12 VDD pmos
M1 o_minus i_plus N1 GND nmos
M4 N4 VDD_en_bar VDD VDD pmos
M12 N12 VDD_en_bar VDD VDD pmos

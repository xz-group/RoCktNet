I1 VCC N0
I2 N7 VEE
I3 N1 VEE
I4 N5 VEE
I5 N6 VEE
M1 N4 N4 VCC VDD pmos
M2 N4 VB N1 GND nmos
M3 VO1 VB N7 GND nmos
M4 VO1 N4 VCC VDD pmos
M5 N7 VEE N0 VDD pmos
M6 N1 VEE N0 VDD pmos
Q1 VCC VMINUS N6 npn
M7 VCC VPLUS N5 GND nmos

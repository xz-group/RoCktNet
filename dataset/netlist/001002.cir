M15 N1 N7 N6 VDD pmos
M17 N1 N7 N4 GND nmos
M14 N0 N2 N6 VDD pmos
M13 N2 N0 N6 VDD pmos
M16 N3 N5 N4 GND nmos
M12 N3 N5 N6 VDD pmos

Is N0 GND Is
Rp N3 Voutn Rp
Rn N4 Voutp Rn
Mp Voutn Vinp N0 GND nmos
Mn Voutp Vinn N0 GND nmos
Ln VDD N4 Ln
Lp VDD N3 Lp

M1 n2 n2 n3 GND nmos
Q1 n0 label_net_0 n1 npn
Q2 n5 label_net_1 n1 npn
M2 n8 n12 n6 VDD pmos
M3 n2 label_net_2 n0 VDD pmos
M4 n11 n11 n6 VDD pmos
M5 n10 n10 n3 GND nmos
I1 n6 n4
M6 n4 n4 n10 GND nmos
M7 n12 label_net_3 n5 VDD pmos
M8 n12 n4 n7 GND nmos
I2 n6 n0
M9 n8 n7 n3 GND nmos
M10 n7 n2 n3 GND nmos
I3 n6 n5
M11 n7 n9 n12 VDD pmos
M12 n9 n9 n11 VDD pmos
I4 n9 n3
I5 n1 n3

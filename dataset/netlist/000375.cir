M9 N10 N1 GND GND nmos
M5 N4 N11 N15 VDD pmos
M_in_p N12 Vin_plus N0 VDD pmos
M10 N12 N1 GND GND nmos
M_bias_n N1 N1 GND GND nmos
MC1 N5 N4 VDD VDD pmos
M3 N15 N9 VDD VDD pmos
MC2_R N5 N3 VDD VDD pmos
M8 N3 N7 N12 GND nmos
M_bias_p LABEL_NET_1 LABEL_NET_1 VDD VDD pmos
MC2_L N2 Vcmset VDD VDD pmos
M7 N4 N7 N10 GND nmos
M11 N0 N16 N5 VDD pmos
M4 N14 N9 VDD VDD pmos
M6 N3 N11 N14 VDD pmos
M16 N1 N16 N2 VDD pmos
MC3 N2 Vcmset VDD VDD pmos
M18 N0 vin_minus N10 GND nmos

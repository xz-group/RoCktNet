A1 (N1 Vref2 N2) amplifier
A2 (N7 VDD N5) amplifier
I1 VDD N2
I2 N9 GND
V1 N3 N0
M1 N5 N4 VDD VDD pmos
Q8 N6 N7 N9 npn
M2 N4 N4 VDD VDD pmos
Q10 N4 N0 N1 npn
Q9 N2 N3 N1 npn
Q6 VDD N7 N8 npn
Q7 N5 Vbias N9 npn
Q3 N8 RFi LABEL_NET_1 npn
Q5 RFo Vbias N8 npn

M1 Vo Vo GND GND nmos
M2 Vo V1 Vo Vo nmos
M3 Vo V2 Vo Vo nmos
M4 Vo V3 Vo Vo nmos

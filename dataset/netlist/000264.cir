M14 NET_A nuitp VDD VDD pmos
M8 NET_A nuitp GND GND nmos
M3 NET_C nuitn VDD VDD pmos
M10 NET_C nuitn GND GND nmos
M13 NET_B NET_A VDD VDD pmos
M18 NET_B NET_C VDD VDD pmos
M2 NET_B NET_C NET_M1_D GND nmos
M1 NET_M1_D NET_A GND GND nmos
M19 NET_H NET_C VDD VDD pmos
M22 NET_H NET_A VDD VDD pmos
M9 NET_H NET_A NET_M6_D GND nmos
M6 NET_M6_D NET_C GND GND nmos
M20 NET_D NET_B VDD VDD pmos
M7 NET_D NET_B GND GND nmos
M15 NET_I NET_H VDD VDD pmos
M4 NET_I NET_H GND GND nmos
I1 NET_TAIL GND
M11 NET_F NET_D NET_TAIL GND nmos
M5 NET_G NET_I NET_TAIL GND nmos
M16 NET_F NET_G VDD VDD pmos
M17 NET_G NET_F VDD VDD pmos
M12 NET_F NET_F VDD VDD pmos
M21 NET_G NET_G VDD VDD pmos

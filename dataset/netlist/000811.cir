M1 N16 N0 N1 GND nmos
M2 N1 N18 Vss VDD pmos
M3 N4 N14 Vss VDD pmos
M4 Vss N9 Vss VDD pmos
M5 N20 N0 N20 GND nmos
M6 N6 N23 Vss VDD pmos
M7 N22 N19 N1 GND nmos
M8 N10 N14 Vss VDD pmos
M9 Out N17 N4 VDD pmos
M10 N19 N1 N22 GND nmos
M11 N21 N9 Vss VDD pmos
M12 N0 N7 N6 VDD pmos
M13 N14 N17 N10 VDD pmos
M14 N17 N0 N1 GND nmos
M15 N9 N16 N21 VDD pmos
M16 N16 N16 Vss VDD pmos
M17 N18 N18 Vss VDD pmos
M18 N14 In_plus N20 GND nmos
M19 N0 N0 LABEL_NET_3 GND nmos
M20 N1 N1 LABEL_NET_4 GND nmos
M21 N19 N16 Vss VDD pmos
M22 N7 N0 N5 GND nmos
M23 N18 N0 N5 GND nmos
M24 N23 N23 Vss VDD pmos
M25 N9 In_minus N20 GND nmos
M26 Out N1 N11 GND nmos
M27 N11 N19 N11 GND nmos
M28 N17 N17 Vss VDD pmos
R1 N5 N5
M29 N7 N7 N23 VDD pmos

M1 N8 N2 N12 VDD pmos
M2 N5 Vin_minus N10 GND nmos
M3 N10 Vb3 N15 GND nmos
M4 Vo_minus N16 N19 GND nmos
M5 Vo_plus N15 N17 GND nmos
M6 N17 N9 GND GND nmos
M7 N2 N18 N20 GND nmos
M8 N20 N7 GND GND nmos
M9 N2 CM_Ref N8 VDD pmos
M10 N5 N2 N11 VDD pmos
M11 N19 N9 GND GND nmos
M12 Vo_plus Vb4 N5 VDD pmos
M13 N5 Vin_plus N10 GND nmos
M14 N9 Vb2 GND GND nmos
M15 N5 N2 N11 VDD pmos
M16 N11 Vo_plus N11 VDD pmos
MT1 N11 Vo_minus LABEL_NET_5 VDD pmos
M18 Vo_minus Vb4 N5 VDD pmos
MT2 N12 CMFB LABEL_NET_6 VDD pmos

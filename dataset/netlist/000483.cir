M1 n2 n0 n7 GND nmos
M2 n8 n2 n6 GND nmos
M3 n7 n5 n3 GND nmos
M4 n5 n1 n8 GND nmos
M5 n6 label_net_0 GND GND nmos
M6 n3 label_net_1 GND GND nmos
M7 n2 n5 n4 VDD pmos
M8 n2 n0 n4 VDD pmos
M9 n3 label_net_2 GND GND nmos
M10 n5 n2 n4 VDD pmos
M11 n5 n1 n4 VDD pmos
M12 n6 label_net_3 GND GND nmos

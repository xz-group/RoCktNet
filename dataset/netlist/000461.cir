M1 n6 label_net_0 n5 VDD pmos
M2 n4 label_net_1 n2 GND nmos
M3 n6 label_net_2 n0 GND nmos
M4 n0 label_net_3 GND GND nmos
M5 n3 label_net_4 VDD VDD pmos
M6 n2 label_net_5 GND GND nmos
M7 n4 label_net_6 n1 VDD pmos
M8 n0 label_net_7 n3 VDD pmos
M9 n2 label_net_8 n3 VDD pmos
M10 n1 label_net_9 VDD VDD pmos
M11 n5 label_net_10 VDD VDD pmos

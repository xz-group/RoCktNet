MP0 N2 N2 VDD VDD pmos
MN0 N2 N2 GND GND nmos
MP1 N2 N2 VDD VDD pmos
MN1 N2 N2 GND GND nmos
MN3 N2 W_WL N2 GND nmos
MN2 N2 W_WL N2 GND nmos
MN5 R_BL_bar R_WL N2 GND nmos
MN4 N2 R_WL N2 GND nmos

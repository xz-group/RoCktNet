M12 N4 N6 GND GND nmos
Ibias N1 GND
M2 N1 N1 VDD VDD pmos
M3 N0 N0 GND GND nmos
M4 N0 N7 VDD VDD pmos
M5 N6 Vin_plus N3 VDD pmos
M6 N4 N1 VDD VDD pmos
M7 N6 N2 GND GND nmos
Cc N4 N9
M8 Vout N7 VDD VDD pmos
M9 N3 N1 VDD VDD pmos
M10 N2 N2 GND GND nmos
M11 N2 Vin_minus N3 VDD pmos
M1 GND N4 Vout VDD pmos
Mc N9 N0 N6 GND nmos

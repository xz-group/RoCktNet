A1 (VCONTROL NET1 NET2) amplifier
I1 VDD NET1 IBIAS
R1 NET1 GND R_POLY_T_SENSOR
M1 NET3 NET2 NET4 GND nmos
R2 NET4 GND R_DEG
R3 VDD NET3 R_POLY_HEATER

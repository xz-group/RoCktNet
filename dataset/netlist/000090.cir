M1 n3 n0 n1 VDD pmos
M2 n1 label_net_0 GND GND nmos
M3 n4 n0 n1 GND nmos
M4 n0 label_net_1 VDD VDD pmos
M5 n1 label_net_2 VDD VDD pmos
M6 n0 n1 n2 VDD pmos
M7 n0 label_net_3 GND GND nmos
M8 n0 n1 n5 GND nmos

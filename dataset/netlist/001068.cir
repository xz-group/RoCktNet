I1 VDD N1
I2 N2 GND
MC17 VDD N1 N2 N2 nmos
MC16 N1 N1 N0 N0 nmos
MC15 N0 N0 Vlow Vlow nmos
MC12 N2 N2 M12Gate M12Gate nmos
MC13 N2 N2 M13Gate M13Gate nmos

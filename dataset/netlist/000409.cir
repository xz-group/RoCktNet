IO VDD N0
M1 N1 N0 VDD VDD pmos
M2 N1 VOUT1 GND GND nmos
M3 N1 VOUT2 GND GND nmos
M4 N0 VCont N1 GND nmos
M10 LABEL_NET_3 N2 VDD VDD pmos
M9 N2 N0 VDD VDD pmos

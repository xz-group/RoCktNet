M1 n2 n1 GND GND nmos
M2 n0 n1 n2 GND nmos
M3 n0 n1 VDD VDD pmos
M4 n2 n1 n0 VDD pmos

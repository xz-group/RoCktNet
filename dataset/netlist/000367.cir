I_UP VDD N1
M1 VDD DN_bar N0 GND nmos
I_DN N0 LABEL_NET_1
M2 Iout DN N0 GND nmos
M3 GND UP N1 VDD pmos
M4 Iout UP_bar N1 VDD pmos

R2 VOUT VDD
R1 VOUT_BAR VDD
M1 N_M1D VRF N_TAIL GND nmos
M2 N_M2D VRF_BAR N_TAIL GND nmos
M3 VOUT VLO N_M1D GND nmos
M4 VOUT_BAR VLO_BAR N_M1D GND nmos
M5 VOUT_BAR VLO N_M2D GND nmos
M6 VOUT VLO_BAR N_M2D GND nmos
I1 N_TAIL GND Itail
R3 VLO_BAR VLODC 1M
R4 VLO VLODC 1M
R5 VRF VRFDC 1M
R6 VRF_BAR VRFDC 1M

I1 N0 GND
I2 N1 GND
Q1 OUT2 In2 N1 npn
Q2 OUT1 In2x N1 npn
Q3 OUT1 In1 N0 npn
Q4 OUT2 In1x N0 npn

R1 VDD n5
R2 VDD n5
I1 n3 GND
I2 n6 GND
M1 n4 n9 n0 GND nmos
M2 n4 n9 n1 GND nmos
M3 n2 n8 n5 GND nmos
M4 n0 n3 n3 GND nmos
M5 n2 n8 n7 GND nmos
M6 n5 n7 n7 GND nmos
M7 n7 label_net_0 n5 VDD pmos
M8 n7 n6 n6 GND nmos
M9 n1 n3 n3 GND nmos
M10 n5 n1 n1 GND nmos
M11 n5 n6 n6 GND nmos
M12 n0 label_net_1 n5 VDD pmos
M13 n5 label_net_2 n5 GND nmos
M14 n5 n0 n0 GND nmos

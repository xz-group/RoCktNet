M1 n3 n9 label_net_1 VDD pmos
M2 n6 label_net_2 n3 VDD pmos
M3 n7 label_net_3 n3 VDD pmos
M4 n2 n1 VDD VDD pmos
M5 n6 n6 n8 GND nmos
M6 n4 n9 VDD VDD pmos
M7 n7 label_net_4 n4 VDD pmos
M8 n7 n7 n8 GND nmos
M9 n6 label_net_5 n4 VDD pmos
M10 n0 n8 n0 GND nmos
M11 n5 label_net_6 n5 GND nmos
M12 n5 n0 n8 GND nmos
M13 n2 n10 n0 GND nmos
M14 n0 label_net_7 n8 GND nmos
M15 n1 n2 VDD VDD pmos
M16 n1 n10 n5 GND nmos

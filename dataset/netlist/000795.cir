M1 Vap Vip n3 GND nmos
M7 Van Van VDD VDD pmos
M9 Van Vap VDD VDD pmos
M2 Vap Vin n2 GND nmos
M5 n2 VB1 VSS GND nmos
M8 Vap Vap VDD VDD pmos
M3 Van VRP n2 GND nmos
M4 Van VRN n3 GND nmos
M6 n3 VB1 VSS GND nmos
M10 VDD Van VDD VDD pmos

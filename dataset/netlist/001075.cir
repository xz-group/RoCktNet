M1 N2 N2 WL VDD pmos
M2 N2 N2 LABEL_NET_1 VDD pmos
M3 N2 N2 GND GND nmos
M4 BL_BAR N3 GND GND nmos
M5 N2 N2 GND GND nmos
M6 N3 N2 BL GND nmos
M7 BL_BAR N2 N3 GND nmos
M8 N2 WL BL GND nmos
M9 BL_BAR WL N2 GND nmos

M1 GND label_net_0 n2 VDD pmos
M2 n0 n0 n1 VDD pmos
M3 n0 n0 GND GND nmos
M4 n0 label_net_1 GND GND nmos
M5 n2 n2 VDD VDD pmos
M6 n1 label_net_2 n2 VDD pmos
M7 n0 n0 GND GND nmos
M8 n0 label_net_3 GND GND nmos
M9 n1 GND n1 VDD pmos
M10 n0 n0 n1 VDD pmos

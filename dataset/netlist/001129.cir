I1 N1 GND
M8 N4 N4 GND GND nmos
M12 N3 Vn1 GND GND nmos
M3 ICO_Control_current N4 GND GND nmos
M4 ICO_Control_current ICO_Control_current GND GND nmos
M5 GND N3 N0 VDD pmos
M6 ICO_Control_current N5 VDD VDD pmos
M7 N4 N3 N0 VDD pmos
M1 ICO_Control_current N1 VDD VDD pmos
M9 N5 N5 VDD VDD pmos
M10 N0 Vp1 VDD VDD pmos
M11 VDD N3 N3 GND nmos
M2 N1 N1 VDD VDD pmos
M13 N5 N3 N3 GND nmos

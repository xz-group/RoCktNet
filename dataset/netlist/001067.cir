I2Ibias N0 GND
MC10 VDD M12Gate N0 GND nmos
MC14 VDD Vhigh N0 GND nmos
MC11 M13Gate M13Gate N0 GND nmos

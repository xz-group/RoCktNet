M1 n1 n0 VDD VDD pmos
M2 n5 n3 n2 GND nmos
M3 n4 n3 n2 GND nmos
M4 n0 label_net_1 n4 GND nmos
M5 n1 label_net_2 n5 GND nmos
M6 VDD label_net_3 n0 GND nmos

M1 N1 GND VDD VDD pmos
M2 GND N1 VDD VDD pmos
MACC GND GND GND GND nmos
M4 N1 GND VDDL GND nmos
M5 GND N1 VDDL GND nmos
M6 N1 GND VDD GND nmos

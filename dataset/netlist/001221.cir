M1 n3 n7 n0 VDD pmos
M2 n0 n1 n2 VDD pmos
M3 n3 n7 n1 VDD pmos
M4 n3 label_net_0 GND GND nmos
M5 n3 label_net_2 GND GND nmos
M6 n5 n6 GND GND nmos
M7 n1 n0 n2 VDD pmos
M8 n3 label_net_3 GND GND nmos
M9 n4 n6 GND GND nmos
M10 n3 label_net_5 GND GND nmos
Q1 n0 label_net_6 n4 npn
Q2 n1 n4 n4 npn
Q3 n0 n0 n5 npn
Q4 n1 n5 n5 npn
M11 n1 label_net_7 n0 GND nmos

M1 VOUTM VIP VSS VSS nmos
M2 N1 VIM VSS VSS nmos
M3 N1 N1 VDD VDD pmos
M4 VOUTM N1 VDD VDD pmos
M5 VOUTP VIM VSS VSS nmos
M6 VOUTP N1 VDD VDD pmos
M7 N1 VIP VSS VSS nmos

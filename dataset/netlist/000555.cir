M1 n0 n0 n0 GND nmos
M2 n0 n0 n0 GND nmos
M3 n0 n0 n1 GND nmos
M4 n0 VDD GND GND nmos
M5 n0 GND n0 VDD pmos
M6 n0 GND n0 VDD pmos
M7 n0 n0 n0 GND nmos
M8 n0 n0 n1 GND nmos
M9 n0 n0 n1 GND nmos

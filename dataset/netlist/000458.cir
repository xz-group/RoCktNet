Mn4 N4 LABEL_NET_0 N0 GND nmos
Mp2 N4 clk VDD VDD pmos
Mn3 N1 LABEL_NET_1 N0 GND nmos
Mp1 N3 clk VDD VDD pmos
Mn2 N4 N1 GND GND nmos
Mn1 N3 N4 GND GND nmos
Mn5 clk bias N0 VDD pmos

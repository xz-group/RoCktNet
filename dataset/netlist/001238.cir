MC14 N0 N0 VDD VDD pmos
MC11 N5 N5 VDD VDD pmos
MC2 N0 Vb2 N1 GND nmos
MC5 Out_n Vb2 N4 GND nmos
MC4 N5 Out_p N1 GND nmos
MC7 N4 Vb1 GND GND nmos
MC12 Out_n N0 VDD VDD pmos
MC8 N1 Vb1 GND GND nmos
MC10 N6 N6 VDD VDD pmos
MC13 N0 N0 VDD VDD pmos
MC3 N0 Vb2 N1 GND nmos
MC1 N6 Out_n N1 GND nmos
MC15 Out_p N0 VDD VDD pmos
MC9 N3 Vb1 GND GND nmos
MC6 Out_p Vb2 N3 GND nmos

I1 N11 GND
M1 Vg N11 VDD VDD pmos
M2 Vg Vg GND GND nmos
M13 Out N5 GND GND nmos
M4 Vg Vg N0 VDD pmos
M5 N2 N2 VDD VDD pmos
M6 N7 N2 VDD VDD pmos
M7 N11 N11 N10 VDD pmos
M8 N8 Vg GND GND nmos
M9 N2 Vg GND GND nmos
M10 N0 N11 VDD VDD pmos
M11 Vg b N3 VDD pmos
M12 N5 In N7 VDD pmos
M3 N3 N11 VDD VDD pmos
M14 Out N5 VDD VDD pmos
M15 N5 In N8 GND nmos
M16 N4 N11 VDD VDD pmos
M17 N10 N11 VDD VDD pmos
M18 Vg a N10 VDD pmos
M19 Vg d N4 VDD pmos

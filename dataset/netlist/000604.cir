M1 n3 label_net_0 VDD VDD pmos
M2 GND label_net_1 GND GND nmos
M3 n1 n3 VDD VDD pmos
M4 n1 label_net_2 VDD VDD pmos
M5 n3 n1 n3 GND nmos
M6 n3 n1 VDD VDD pmos
M7 GND VDD GND GND nmos
M8 n2 label_net_3 GND n0 nmos
M9 n1 n3 n2 GND nmos
M10 n0 n0 GND n0 nmos
M11 n0 label_net_4 n0 n0 pmos
M12 n0 label_net_5 n0 GND nmos
M13 n0 label_net_6 n0 n0 nmos

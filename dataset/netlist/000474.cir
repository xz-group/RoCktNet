M1 label_net_0 n2 n0 GND nmos
M2 label_net_3 n1 n0 GND nmos
M3 n2 GND label_net_4 VDD pmos
M4 n0 label_net_5 GND GND nmos
M5 n1 GND label_net_6 VDD pmos

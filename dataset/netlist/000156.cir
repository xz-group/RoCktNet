I1 n0 label_net_0
M1 n2 n1 n4 GND nmos
M2 n1 n1 n4 GND nmos
M3 n5 n3 n4 GND nmos
M4 n3 label_net_1 n6 VDD pmos
M5 n6 n0 VDD VDD pmos
M6 n3 n3 n4 GND nmos
M7 n1 label_net_2 n6 VDD pmos
M8 n2 n2 VDD VDD pmos
M9 n5 n2 VDD VDD pmos
M10 n0 n0 VDD VDD pmos

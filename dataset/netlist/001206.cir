M1 n0 n2 GND GND nmos
M2 n1 n3 GND GND nmos
M3 n1 n0 GND GND nmos
M4 n0 n1 GND GND nmos
M5 n0 n1 VDD VDD pmos
M6 n1 n0 VDD VDD pmos
M7 n0 n0 GND GND nmos
M8 n0 n0 label_net_0 VDD pmos
M9 n1 n1 GND GND nmos
M10 n0 n2 VDD VDD pmos
Q1 label_net_1 n1 n1 npn
M11 n1 n3 VDD VDD pmos

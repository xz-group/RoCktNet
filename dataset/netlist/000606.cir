MI2 N5 R_P GND GND nmos
M13 N13 N13 GND GND nmos
M3 N11 N11 GND GND nmos
M18 N7 N16 VDD VDD pmos
M10 out_p N0 GND GND nmos
M5 N3 out_p in1 VDD pmos
M8 N0 N3 GND GND nmos
M6 N0 in1 in1 VDD pmos
M15 N16 out_n N1 GND nmos
M17 N16 N16 VDD VDD pmos
M1 N6 N6 VDD VDD pmos
M19 out_n N7 VDD VDD pmos
M7 N3 N3 GND GND nmos
M16 N7 in2 N1 GND nmos
M20 out_n N14 GND GND nmos
MTG1_1 out_p R_P out1 GND nmos
Mdummy VDD VDD VDD VDD pmos
M4 in1 N6 VDD VDD pmos
MI1 N5 R_P VDD VDD pmos
M9 out_p N6 VDD VDD pmos
M21 out_p N5 out1 GND nmos
M12 N13 N13 N15 VDD pmos
M23 out_p N5 out1 GND nmos
M24 out_n R_P out1 GND nmos
M2 N6 N6 N11 GND nmos
M26 out_n N5 out1 GND nmos
M27 out_p R_P out1 GND nmos
M28 N5 N5 out1 GND nmos
M14 N1 N13 N14 GND nmos
M11 N15 LABEL_NET_1 VDD VDD pmos
M31 out_n R_P out1 GND nmos

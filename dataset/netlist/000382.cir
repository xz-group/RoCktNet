M1 OUT OUT VDD VDD pmos
M2 N1 IN VDD VDD pmos
M3 OUT IN GND GND nmos
M4 N1 IN GND GND nmos
M5 OUT N1 GND GND nmos
M6 OUT OUT VDD VDD pmos

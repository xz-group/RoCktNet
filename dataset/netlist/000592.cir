M1 n5 n4 GND GND nmos
M2 n1 label_net_0 n5 VDD pmos
M3 n3 label_net_1 n0 VDD pmos
M4 n0 n1 GND GND nmos
M5 n5 n4 VDD VDD pmos
M6 n0 n1 VDD VDD pmos
M7 n0 n2 GND GND nmos
M8 n0 n2 VDD VDD pmos
M9 n5 n3 GND GND nmos
M10 n3 label_net_2 n0 GND nmos
M11 n5 n3 VDD VDD pmos
M12 n1 label_net_3 n5 GND nmos

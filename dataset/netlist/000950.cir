M1 N0 v1n N1 GND nmos
M2 von vop N4 GND nmos
M3 vop von VDD VDD pmos
M4 vop von N0 GND nmos
M5 N0 Clock VDD VDD pmos
M6 vop Clock VDD VDD pmos
M7 N1 Clock GND GND nmos
M8 von Clock VDD VDD pmos
M9 von vop VDD VDD pmos
M10 N4 Clock VDD VDD pmos
M11 N4 v1p N1 GND nmos

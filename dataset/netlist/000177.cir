Iu VDD N2
Id N3 GND
M1 N2 Vund Vref GND nmos
M2 N2 Vun Iout GND nmos
M3 Vref Vupd N2 VDD pmos
M4 Vref Vdnd N3 GND nmos
M5 Iout Vdn N3 GND nmos
M6 N3 Vdpd Vref VDD pmos
M7 N3 Vdp Iout VDD pmos
M8 Iout Vup N2 VDD pmos

M1 N4 A GND GND nmos
M2 N5 B GND GND nmos
M3 Out B N4 GND nmos
M4 Out A N5 GND nmos
M5 Out A VDD VDD pmos
M6 Out B VDD VDD pmos

M1 VB3 N_CMFB GND GND nmos
M2 N_FOLD1 N_CMFB GND GND nmos
M3 Von Von N_FOLD1 GND nmos
M4 N_FOLD2 VB3 GND GND nmos
M5 N_FOLD1 VB3 GND GND nmos
M6 N_CMFB Vcm N_TAIL VDD pmos
M7 N_CASC_P1 VB1 VDD VDD pmos
M8 N_CMFB N_CMFB GND GND nmos
M9 N7 VB1 VDD VDD pmos
M10 Von Von N_CASC_P1 VDD pmos
M11 N_CMFB N_CMFB GND GND nmos
M12 VB3 N_CMFB N_TAIL VDD pmos
M13 N_FOLD1 Vip N_TAIL VDD pmos
M14 Vop Vop N_FOLD2 GND nmos
M15 N_CASC_P2 VB1 VDD VDD pmos
M16 N_TAIL VB2 N7 VDD pmos
M17 N_CMFB Vcm N_TAIL VDD pmos
M18 Vop Vop N_CASC_P2 VDD pmos

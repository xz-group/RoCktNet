M5 Vo_n Vcf3 N1 VDD pmos
S1 (N1 phi_bar VDD VDD) pmos
M3 Vo_n VB3 N8 GND nmos
M6 Vo_p Vcf3 N1 VDD pmos
M4 N7 Vi_n N2 GND nmos
M7 N5 VB2 GND GND nmos
S2 (N2 phi N5 GND) nmos
M1 N8 Vi_p N2 GND nmos
M10 Vo_p VB3 N7 GND nmos

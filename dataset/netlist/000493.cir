ib1 VDD VbiasN
M1 N2 N2 GND GND nmos
mp3 N4 N4 VDD VDD pmos
Q1 N0 IN- N8 npn
M4 N2 Vbias N0 VDD pmos
Q2 N1 IN+ N8 npn
mn3 N10 N10 GND GND nmos
I2 VDD N0
mn1 Vg_PCH VbiasN Vg_NCH GND nmos
M7 Vg_NCH N2 GND GND nmos
M8 Vg_PCH Vbias N1 VDD pmos
mn2 VbiasN VbiasN N10 GND nmos
mp2 VbiasP VbiasP N4 VDD pmos
mp1 Vg_NCH VbiasP Vg_PCH VDD pmos
ib3 VDD N1
ib2 VbiasP GND
I5 N8 GND

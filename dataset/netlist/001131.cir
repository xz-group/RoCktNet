M7 N1 BP VDD VDD pmos
M2 O1 VN N1 VDD pmos
M3 O2 VP N1 VDD pmos
M10 O1 BN GND GND nmos
M11 O2 BN GND GND nmos
M12 O1 O1 GND GND nmos
M13 O2 O2 GND GND nmos

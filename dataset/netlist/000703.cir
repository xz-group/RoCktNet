M1 n2 n0 n4 GND nmos
M2 n4 label_net_0 VDD VDD pmos
M3 n0 n2 n1 GND nmos
M4 n4 label_net_1 n3 GND nmos
M5 n1 label_net_2 n3 GND nmos
M6 n1 label_net_3 VDD VDD pmos
M7 n3 label_net_4 GND GND nmos
M8 n0 label_net_5 VDD VDD pmos
M9 n2 label_net_6 VDD VDD pmos
M10 n2 n0 VDD VDD pmos
M11 n0 n2 VDD VDD pmos

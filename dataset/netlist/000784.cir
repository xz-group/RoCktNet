M1 N6 N4 GND GND nmos
M2 N0 N2 GND GND nmos
M3 N4 N4 GND GND nmos
M4 N3 N1 VDD VDD pmos
M5 N4 N4 VDD VDD pmos
M6 N1 N1 VDD VDD pmos
M7 N3 V_BIAS N6 GND nmos
M8 N1 V_N N0 GND nmos
M9 V_AMP N2 GND GND nmos
M10 N3 N4 VDD VDD pmos
M11 N3 V_P N0 GND nmos
M12 N2 N2 VDD VDD pmos
M13 V_AMP N3 VDD VDD pmos
M14 N2 GND GND GND nmos
C_COMP V_AMP N6
